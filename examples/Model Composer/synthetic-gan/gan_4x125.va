// gan_4x125: a composed FET written as Verilog-A by circuitRF 1.5.0, from gan_4x125.cmodel.
// Model created 2026-10-20T00:00:00Z by circuitRF 1.0.14; model.json SHA-256 a03a7c198155c45045d664860a1681ff81cad19865f683bbf044f43420a24d3d.
//
// Terminals: g (gate), d (drain), s (source), t (thermal: its temperature is the channel's rise above the
// ambient, K). Leave t unconnected and the model heats on its own network; wire it and whatever is attached
// sits in parallel with that network. Every current, charge and network value scales from the
// measured device's N0 = 4 fingers to N; the host's own device multiplier (m) multiplies the whole
// device, so the module declares none.
//
// Parameters: name, unit, default, meaning.
//   N            -       4                       finger count, a whole number; the model was measured at N0 = 4 (125 um each)
//   Temp         degC    unset                   the device's temperature; unset follows the simulator's, clamped to the model's 25.0 to 125.0 degC; a self-heating device's channel rises above it
//   Rth          degC/W  unset                   the device's own DC thermal resistance at N fingers; unset (0) is the model's, x N0/N
//   Cth          J/degC  unset                   the device's own total thermal capacitance at N fingers; unset (0) is the model's, x N/N0
//   Charge       -       1                       0: no intrinsic charge (the network's capacitors and the state nodes' own charges stay)
//   LinearC      -       0                       1: the intrinsic charge linearised at the bias point VgsQ, VdsQ, TjQ
//   LinearCgs    -       0                       1: Cgs = C11 + C12 held at its bias-point value, the others following the model
//   LinearCdg    -       0                       1: Cdg = -C12 held at its bias-point value
//   LinearCds    -       0                       1: Cds = C22 + C12 held at its bias-point value
//   LinearCm     -       0                       1: the transcapacitance Cm = C21 - C12 held at its bias-point value
//   GateLag      -       1                       0: every gate-lag trap state takes its DC value at the instantaneous voltages; does nothing here: the model has no gate-lag trap state
//   DrainLag     -       1                       0: every drain-lag trap state takes its DC value at the instantaneous voltages
//   SelfHeating  -       1                       0: evaluated at the ambient, no power into the thermal network
//   Dispersion   -       1                       0: the drain carries IdDC at every frequency; does nothing here: the model has no DC/RF dispersion
//   VgsQ         V       unset                   the INTRINSIC gate-source voltage at the bias point the linear-charge switches freeze at
//   VdsQ         V       unset                   the INTRINSIC drain-source voltage at the bias point
//   TjQ          degC    unset                   the junction temperature at the bias point; unset is the device's temperature (for a self-heating device, the ambient plus the DC rise)
//   Cpga         F       7e-15                   network variable
//   Cpda         F       7e-15                   network variable
//   Cpdga        F       5e-16                   network variable
//   Cpgi         F       4.900000000000001e-15   network variable, scaled x N/N0 (perFinger)
//   Cpdi         F       2.1000000000000002e-14  network variable, scaled x N/N0 (perFinger)
//   Cpdgi        F       1e-15                   network variable, scaled x N/N0 (perFinger)
//   Lg           H       4.499606686534066e-11   network variable
//   Ld           H       5.199394684027272e-11   network variable
//   Ls           H       6.4952364348079525e-12  network variable
//   M_feedback   H       1e-12                   network variable
//   rg           Ohm     5.2                     network variable, scaled x N0/N (perFingerInverse)
//   rd           Ohm     9.2                     network variable, scaled x N0/N (perFingerInverse)
//   rs           Ohm     6.6                     network variable, scaled x N0/N (perFingerInverse)
//   Gx_Id        S       5.152940819955758       the cap on guided extrapolation's added conductance on Id's own branch (ten times the edge's own), at the base periphery
//   Gx_IgGs      S       16.536007846158178      the cap on guided extrapolation's added conductance on IgGs's own branch (ten times the edge's own), at the base periphery
//   Gx_IgGd      S       2.020491003112437e-09   the cap on guided extrapolation's added conductance on IgGd's own branch (ten times the edge's own), at the base periphery
//   TauCapt2     s       1e-08                   drain-lag capture time at the reference gap
//   TauEmit2     s       0.001                   drain-lag emission time (at Tref when thermally activated)
//   Xref         V       1.0                     the reference gap at which capture takes TauCapt
//   Vc           V       0.05                    how fast capture slows as the gap closes
//   Tref         degC    25.0                    the temperature at which TauEmit holds
//
// Temperature: the constituents read T, the device's temperature held to 25.0 to 125.0 degC;
// a device outside that says so once, as a warning at the first step.
// Self-heating: T is that temperature plus the rise of the internal node ti, which the dissipated power
// ig*vgs + id*vds heats through the thermal network.
// Switches: Charge, LinearC, LinearCgs, LinearCdg, LinearCds, LinearCm, GateLag, DrainLag, SelfHeating and Dispersion, as a
// placed ComposedFET has them; 1 is on. For this model GateLag and Dispersion do nothing.
// The bias point: LinearC and the four branch switches hold the intrinsic charge at VgsQ, VdsQ and TjQ, which
// circuitRF finds itself from a DC solve and this module cannot. VgsQ and VdsQ are the INTRINSIC voltages,
// V(gi, si) and V(di, si), which differ from the terminal bias by the drops on the network's resistances.
// Unset (-1e+300) with such a switch on stops the run ($fatal) at the first step.
// A constituent that evaluates to a number that is not finite stops the run ($fatal), naming it and the point.

`include "disciplines.vams"
`include "constants.vams"

module gan_4x125(g, d, s, t);
  inout g, d, s, t;
  electrical g, d, s;
  thermal t;
  // Network.Netlist pins 4-6: the intrinsic gate, drain and source
  electrical gi, di, si;
  // Network.Netlist internal nets
  electrical n1, n3, n2;
  // Traps: one node per enabled state, its voltage the state, V
  electrical phi2;
  // Thermal: the network's own nodes; their temperature is the rise above the ambient, K
  thermal ti;
  // Network.Netlist inductors: each a branch whose current is an unknown
  branch (g, n1) br_L1;
  branch (d, n3) br_L2;
  branch (s, n2) br_L3;

  // Parameters (the header lists them with their units)
  parameter integer N = 4 from [1:inf);
  parameter real Temp = -273.15 from [-273.15:inf);
  parameter real Rth = 0.0 from [0:inf);
  parameter real Cth = 0.0 from [0:inf);
  parameter integer Charge = 1 from [0:1];
  parameter integer LinearC = 0 from [0:1];
  parameter integer LinearCgs = 0 from [0:1];
  parameter integer LinearCdg = 0 from [0:1];
  parameter integer LinearCds = 0 from [0:1];
  parameter integer LinearCm = 0 from [0:1];
  parameter integer GateLag = 1 from [0:1];
  parameter integer DrainLag = 1 from [0:1];
  parameter integer SelfHeating = 1 from [0:1];
  parameter integer Dispersion = 1 from [0:1];
  parameter real VgsQ = -1e+300;
  parameter real VdsQ = -1e+300;
  parameter real TjQ = -273.15 from [-273.15:inf);
  parameter real Cpga = 7e-15;
  parameter real Cpda = 7e-15;
  parameter real Cpdga = 5e-16;
  parameter real Cpgi = 4.900000000000001e-15;
  parameter real Cpdi = 2.1000000000000002e-14;
  parameter real Cpdgi = 1e-15;
  parameter real Lg = 4.499606686534066e-11;
  parameter real Ld = 5.199394684027272e-11;
  parameter real Ls = 6.4952364348079525e-12;
  parameter real M_feedback = 1e-12;
  parameter real rg = 5.2 from (0:inf);
  parameter real rd = 9.2 from (0:inf);
  parameter real rs = 6.6 from (0:inf);
  parameter real Gx_Id = 5.152940819955758 from (0:inf);
  parameter real Gx_IgGs = 16.536007846158178 from (0:inf);
  parameter real Gx_IgGd = 2.020491003112437e-09 from (0:inf);
  parameter real TauCapt2 = 1e-08 from (0:inf);
  parameter real TauEmit2 = 0.001 from (0:inf);
  parameter real Xref = 1.0 from (0:inf);
  parameter real Vc = 0.05 from (0:inf);
  parameter real Tref = 25.0 from (-273.15:inf);

  // The core's constituents: each payload a function returning its value and writing its gradient into
  // the d_ outputs; a table or ANN is evaluated at the nearest point of its training domain and continued.

  // Core.Constituents.Id.Network (ANN, 2 hidden layers of 16 x 16, Tanh)
  analog function real f_Id;
    input vgs, vds, T, phi2;
    output d_vgs, d_vds, d_T, d_phi2;
    real vgs, vds, T, phi2;
    real d_vgs, d_vds, d_T, d_phi2;
    real z, x1, x2, x3, x4, h1_1, h1_1_vgs, h1_1_vds, h1_1_T, h1_1_phi2, h1_2, h1_2_vgs;
    real h1_2_vds, h1_2_T, h1_2_phi2, h1_3, h1_3_vgs, h1_3_vds, h1_3_T, h1_3_phi2, h1_4, h1_4_vgs, h1_4_vds, h1_4_T;
    real h1_4_phi2, h1_5, h1_5_vgs, h1_5_vds, h1_5_T, h1_5_phi2, h1_6, h1_6_vgs, h1_6_vds, h1_6_T, h1_6_phi2, h1_7;
    real h1_7_vgs, h1_7_vds, h1_7_T, h1_7_phi2, h1_8, h1_8_vgs, h1_8_vds, h1_8_T, h1_8_phi2, h1_9, h1_9_vgs, h1_9_vds;
    real h1_9_T, h1_9_phi2, h1_10, h1_10_vgs, h1_10_vds, h1_10_T, h1_10_phi2, h1_11, h1_11_vgs, h1_11_vds, h1_11_T, h1_11_phi2;
    real h1_12, h1_12_vgs, h1_12_vds, h1_12_T, h1_12_phi2, h1_13, h1_13_vgs, h1_13_vds, h1_13_T, h1_13_phi2, h1_14, h1_14_vgs;
    real h1_14_vds, h1_14_T, h1_14_phi2, h1_15, h1_15_vgs, h1_15_vds, h1_15_T, h1_15_phi2, h1_16, h1_16_vgs, h1_16_vds, h1_16_T;
    real h1_16_phi2, h2_1, h2_1_vgs, h2_1_vds, h2_1_T, h2_1_phi2, h2_2, h2_2_vgs, h2_2_vds, h2_2_T, h2_2_phi2, h2_3;
    real h2_3_vgs, h2_3_vds, h2_3_T, h2_3_phi2, h2_4, h2_4_vgs, h2_4_vds, h2_4_T, h2_4_phi2, h2_5, h2_5_vgs, h2_5_vds;
    real h2_5_T, h2_5_phi2, h2_6, h2_6_vgs, h2_6_vds, h2_6_T, h2_6_phi2, h2_7, h2_7_vgs, h2_7_vds, h2_7_T, h2_7_phi2;
    real h2_8, h2_8_vgs, h2_8_vds, h2_8_T, h2_8_phi2, h2_9, h2_9_vgs, h2_9_vds, h2_9_T, h2_9_phi2, h2_10, h2_10_vgs;
    real h2_10_vds, h2_10_T, h2_10_phi2, h2_11, h2_11_vgs, h2_11_vds, h2_11_T, h2_11_phi2, h2_12, h2_12_vgs, h2_12_vds, h2_12_T;
    real h2_12_phi2, h2_13, h2_13_vgs, h2_13_vds, h2_13_T, h2_13_phi2, h2_14, h2_14_vgs, h2_14_vds, h2_14_T, h2_14_phi2, h2_15;
    real h2_15_vgs, h2_15_vds, h2_15_T, h2_15_phi2, h2_16, h2_16_vgs, h2_16_vds, h2_16_T, h2_16_phi2, u, u_vgs, u_vds;
    real u_T, u_phi2;
    begin
      x1 = (vgs - (-2.075844497250043))*0.3419790770358771;
      x2 = (vds - 9.999999999453182)*0.1000000000048878;
      x3 = (T - 75.0)*0.02;
      x4 = (phi2 - 9.9999999999008)*0.10000000000084802;
      // hidden layer 1
      z = -1.5933119499085566 + 0.12829381842850873*x1 + 0.9208290877657501*x2 - 0.15835532264460822*x3 - 0.43969830300161183*x4;
      h1_1 = tanh(z);
      h1_1_vgs = (1.0 - h1_1*h1_1)*(0.04387380161558982);
      h1_1_vds = (1.0 - h1_1*h1_1)*(0.09208290878107585);
      h1_1_T = (1.0 - h1_1*h1_1)*(-0.0031671064528921646);
      h1_1_phi2 = (1.0 - h1_1*h1_1)*(-0.04396983030053406);
      z = -1.3486318028066393 + 2.813862473309755*x1 + 2.3373242547907593*x2 - 0.4952943473447844*x3 + 0.44095792645954135*x4;
      h1_2 = tanh(z);
      h1_2_vgs = (1.0 - h1_2*h1_2)*(0.9622820915283603);
      h1_2_vds = (1.0 - h1_2*h1_2)*(0.23373242549050033);
      h1_2_T = (1.0 - h1_2*h1_2)*(-0.009905886946895688);
      h1_2_phi2 = (1.0 - h1_2*h1_2)*(0.044095792646328076);
      z = -2.5451056245224977 + 0.27282404167708885*x1 - 2.4366620592430905*x2 - 0.36181564859510323*x3 + 2.6746999671064335*x4;
      h1_3 = tanh(z);
      h1_3_vgs = (1.0 - h1_3*h1_3)*(0.09330011396592851);
      h1_3_vds = (1.0 - h1_3*h1_3)*(-0.243666205936219);
      h1_3_T = (1.0 - h1_3*h1_3)*(-0.007236312971902065);
      h1_3_phi2 = (1.0 - h1_3*h1_3)*(0.26746999671291155);
      z = -2.281092619472763 + 1.3436628705228981*x1 - 0.9332497777538844*x2 + 0.0019555471481095253*x3 + 0.3471034033412662*x4;
      h1_4 = tanh(z);
      h1_4_vgs = (1.0 - h1_4*h1_4)*(0.4595045883087979);
      h1_4_vds = (1.0 - h1_4*h1_4)*(-0.09332497777994998);
      h1_4_T = (1.0 - h1_4*h1_4)*(3.9110942962190505e-05);
      h1_4_phi2 = (1.0 - h1_4*h1_4)*(0.03471034033442097);
      z = -1.3649487691870426 + 1.3418021025937987*x1 - 0.08059496966477132*x2 - 0.1278503434519119*x3 + 0.14917333932430923*x4;
      h1_5 = tanh(z);
      h1_5_vgs = (1.0 - h1_5*h1_5)*(0.45886824460982656);
      h1_5_vds = (1.0 - h1_5*h1_5)*(-0.008059496966871065);
      h1_5_T = (1.0 - h1_5*h1_5)*(-0.002557006869038238);
      h1_5_phi2 = (1.0 - h1_5*h1_5)*(0.014917333932557425);
      z = -4.206325726855275 + 0.7878710867456082*x1 - 3.936062311666141*x2 - 0.09325157253654331*x3 - 0.60434062243573*x4;
      h1_6 = tanh(z);
      h1_6_vgs = (1.0 - h1_6*h1_6)*(0.2694354270685166);
      h1_6_vds = (1.0 - h1_6*h1_6)*(-0.3936062311858528);
      h1_6_T = (1.0 - h1_6*h1_6)*(-0.0018650314507308663);
      h1_6_phi2 = (1.0 - h1_6*h1_6)*(-0.06043406224408549);
      z = -1.3694200989764673 + 1.4286725415988237*x1 + 0.10364824578145684*x2 - 0.11011984141465483*x3 - 0.17913809169617514*x4;
      h1_7 = tanh(z);
      h1_7_vgs = (1.0 - h1_7*h1_7)*(0.48857611716246646);
      h1_7_vds = (1.0 - h1_7*h1_7)*(0.010364824578652296);
      h1_7_T = (1.0 - h1_7*h1_7)*(-0.0022023968282930966);
      h1_7_phi2 = (1.0 - h1_7*h1_7)*(-0.017913809169769427);
      z = 2.6528102142158674 + 0.01424677746794535*x1 + 0.869944324855413*x2 + 0.0017205562117793068*x3 + 2.44196470742214*x4;
      h1_8 = tanh(z);
      h1_8_vgs = (1.0 - h1_8*h1_8)*(0.004872099809223481);
      h1_8_vds = (1.0 - h1_8*h1_8)*(0.08699443248979341);
      h1_8_T = (1.0 - h1_8*h1_8)*(3.441112423558614e-05);
      h1_8_phi2 = (1.0 - h1_8*h1_8)*(0.24419647074428483);
      z = -3.4838314555784486 + 0.8051269366284499*x1 - 2.8274366576568792*x2 - 0.010503398596473874*x3 + 0.15571819399370632*x4;
      h1_9 = tanh(z);
      h1_9_vgs = (1.0 - h1_9*h1_9)*(0.2753365666849204);
      h1_9_vds = (1.0 - h1_9*h1_9)*(-0.2827436657795079);
      h1_9_T = (1.0 - h1_9*h1_9)*(-0.0002100679719294775);
      h1_9_phi2 = (1.0 - h1_9*h1_9)*(0.015571819399502683);
      z = -1.3923874300272512 + 0.5327513915920561*x1 - 0.9386070971330501*x2 + 0.17000273450286352*x3 + 0.20635386096769845*x4;
      h1_10 = tanh(z);
      h1_10_vgs = (1.0 - h1_10*h1_10)*(0.18218982918623047);
      h1_10_vds = (1.0 - h1_10*h1_10)*(-0.09386070971789275);
      h1_10_T = (1.0 - h1_10*h1_10)*(0.0034000546900572704);
      h1_10_phi2 = (1.0 - h1_10*h1_10)*(0.020635386096944836);
      z = -2.686691799206774 - 0.5572444097190697*x1 + 0.969073987825464*x2 + 0.3420111215560285*x3 - 2.054283094375811*x4;
      h1_11 = tanh(z);
      h1_11_vgs = (1.0 - h1_11*h1_11)*(-0.1905659289191296);
      h1_11_vds = (1.0 - h1_11*h1_11)*(0.09690739878728304);
      h1_11_T = (1.0 - h1_11*h1_11)*(0.00684022243112057);
      h1_11_phi2 = (1.0 - h1_11*h1_11)*(-0.2054283094393232);
      z = 0.6328536742765163 - 3.2417523409773863*x1 - 0.38864870767202736*x2 + 0.003972010331110435*x3 + 0.45189737397338225*x4;
      h1_12 = tanh(z);
      h1_12_vgs = (1.0 - h1_12*h1_12)*(-1.1086114735463406);
      h1_12_vds = (1.0 - h1_12*h1_12)*(-0.038864870769102375);
      h1_12_T = (1.0 - h1_12*h1_12)*(7.94402066222087e-05);
      h1_12_phi2 = (1.0 - h1_12*h1_12)*(0.04518973739772145);
      z = 1.5419458852163255 + 0.431933200354336*x1 + 0.5360440002686854*x2 - 0.1796666258448341*x3 - 0.4796402743329499*x4;
      h1_13 = tanh(z);
      h1_13_vgs = (1.0 - h1_13*h1_13)*(0.1477121171983284);
      h1_13_vds = (1.0 - h1_13*h1_13)*(0.053604400029488616);
      h1_13_T = (1.0 - h1_13*h1_13)*(-0.003593332516896682);
      h1_13_phi2 = (1.0 - h1_13*h1_13)*(-0.04796402743370174);
      z = 1.4569529180656706 - 1.8783322405179743*x1 - 0.9615179689327059*x2 + 0.19673583588109556*x3 + 0.6036365652683513*x4;
      h1_14 = tanh(z);
      h1_14_vgs = (1.0 - h1_14*h1_14)*(-0.6423503259790679);
      h1_14_vds = (1.0 - h1_14*h1_14)*(-0.0961517968979703);
      h1_14_T = (1.0 - h1_14*h1_14)*(0.003934716717621911);
      h1_14_phi2 = (1.0 - h1_14*h1_14)*(0.06036365652734703);
      z = -0.10209267732787135 - 0.30132821641543817*x1 - 0.37322121124687874*x2 - 0.10998062550270313*x3 + 0.45516546084497983*x4;
      h1_15 = tanh(z);
      h1_15_vgs = (1.0 - h1_15*h1_15)*(-0.10304794533461857);
      h1_15_vds = (1.0 - h1_15*h1_15)*(-0.037322121126512106);
      h1_15_T = (1.0 - h1_15*h1_15)*(-0.0021996125100540624);
      h1_15_phi2 = (1.0 - h1_15*h1_15)*(0.04551654608488397);
      z = -0.23463079582722346 - 0.09585488942309765*x1 - 0.5471074069864692*x2 + 0.11115450100658476*x3 + 0.1150641677042555*x4;
      h1_16 = tanh(z);
      h1_16_vgs = (1.0 - h1_16*h1_16)*(-0.032780366614286995);
      h1_16_vds = (1.0 - h1_16*h1_16)*(-0.05471074070132107);
      h1_16_T = (1.0 - h1_16*h1_16)*(0.0022230900201316954);
      h1_16_phi2 = (1.0 - h1_16*h1_16)*(0.011506416770523126);
      // hidden layer 2
      z = 0.7524336429826565 - 0.6733364145595558*h1_1 - 0.1360856492106061*h1_2 - 0.4649270955806216*h1_3 - 1.3675534327258687*h1_4 - 0.05141069429916224*h1_5 + 0.021296602359882504*h1_6 + 0.2067701760858152*h1_7 - 0.21197846582645116*h1_8 + 0.18864458977755272*h1_9 - 0.05652183036578407*h1_10 - 0.6262469960238269*h1_11 + 1.5735402938782546*h1_12 - 0.2024120057492176*h1_13 + 0.44674624332950447*h1_14 - 0.35033187822885714*h1_15 - 0.22343315969936364*h1_16;
      h2_1 = tanh(z);
      h2_1_vgs = (1.0 - h2_1*h2_1)*(- 0.6733364145595558*h1_1_vgs - 0.1360856492106061*h1_2_vgs - 0.4649270955806216*h1_3_vgs - 1.3675534327258687*h1_4_vgs - 0.05141069429916224*h1_5_vgs + 0.021296602359882504*h1_6_vgs + 0.2067701760858152*h1_7_vgs - 0.21197846582645116*h1_8_vgs + 0.18864458977755272*h1_9_vgs - 0.05652183036578407*h1_10_vgs - 0.6262469960238269*h1_11_vgs + 1.5735402938782546*h1_12_vgs - 0.2024120057492176*h1_13_vgs + 0.44674624332950447*h1_14_vgs - 0.35033187822885714*h1_15_vgs - 0.22343315969936364*h1_16_vgs);
      h2_1_vds = (1.0 - h2_1*h2_1)*(- 0.6733364145595558*h1_1_vds - 0.1360856492106061*h1_2_vds - 0.4649270955806216*h1_3_vds - 1.3675534327258687*h1_4_vds - 0.05141069429916224*h1_5_vds + 0.021296602359882504*h1_6_vds + 0.2067701760858152*h1_7_vds - 0.21197846582645116*h1_8_vds + 0.18864458977755272*h1_9_vds - 0.05652183036578407*h1_10_vds - 0.6262469960238269*h1_11_vds + 1.5735402938782546*h1_12_vds - 0.2024120057492176*h1_13_vds + 0.44674624332950447*h1_14_vds - 0.35033187822885714*h1_15_vds - 0.22343315969936364*h1_16_vds);
      h2_1_T = (1.0 - h2_1*h2_1)*(- 0.6733364145595558*h1_1_T - 0.1360856492106061*h1_2_T - 0.4649270955806216*h1_3_T - 1.3675534327258687*h1_4_T - 0.05141069429916224*h1_5_T + 0.021296602359882504*h1_6_T + 0.2067701760858152*h1_7_T - 0.21197846582645116*h1_8_T + 0.18864458977755272*h1_9_T - 0.05652183036578407*h1_10_T - 0.6262469960238269*h1_11_T + 1.5735402938782546*h1_12_T - 0.2024120057492176*h1_13_T + 0.44674624332950447*h1_14_T - 0.35033187822885714*h1_15_T - 0.22343315969936364*h1_16_T);
      h2_1_phi2 = (1.0 - h2_1*h2_1)*(- 0.6733364145595558*h1_1_phi2 - 0.1360856492106061*h1_2_phi2 - 0.4649270955806216*h1_3_phi2 - 1.3675534327258687*h1_4_phi2 - 0.05141069429916224*h1_5_phi2 + 0.021296602359882504*h1_6_phi2 + 0.2067701760858152*h1_7_phi2 - 0.21197846582645116*h1_8_phi2 + 0.18864458977755272*h1_9_phi2 - 0.05652183036578407*h1_10_phi2 - 0.6262469960238269*h1_11_phi2 + 1.5735402938782546*h1_12_phi2 - 0.2024120057492176*h1_13_phi2 + 0.44674624332950447*h1_14_phi2 - 0.35033187822885714*h1_15_phi2 - 0.22343315969936364*h1_16_phi2);
      z = 1.6649194845804838 - 1.024154191212115*h1_1 - 1.997463228286444*h1_2 + 0.3957053892055906*h1_3 + 1.0662805851868935*h1_4 - 0.6247825032813225*h1_5 + 0.9742281394935626*h1_6 - 0.7162936763136747*h1_7 + 1.8306656275340027*h1_8 - 1.3204123886257413*h1_9 - 0.4546156159382238*h1_10 - 1.6883609260324741*h1_11 + 0.2851563780872549*h1_12 + 0.4103240621926418*h1_13 + 0.6190175732580496*h1_14 - 0.46870661031646266*h1_15 - 0.38361114024640103*h1_16;
      h2_2 = tanh(z);
      h2_2_vgs = (1.0 - h2_2*h2_2)*(- 1.024154191212115*h1_1_vgs - 1.997463228286444*h1_2_vgs + 0.3957053892055906*h1_3_vgs + 1.0662805851868935*h1_4_vgs - 0.6247825032813225*h1_5_vgs + 0.9742281394935626*h1_6_vgs - 0.7162936763136747*h1_7_vgs + 1.8306656275340027*h1_8_vgs - 1.3204123886257413*h1_9_vgs - 0.4546156159382238*h1_10_vgs - 1.6883609260324741*h1_11_vgs + 0.2851563780872549*h1_12_vgs + 0.4103240621926418*h1_13_vgs + 0.6190175732580496*h1_14_vgs - 0.46870661031646266*h1_15_vgs - 0.38361114024640103*h1_16_vgs);
      h2_2_vds = (1.0 - h2_2*h2_2)*(- 1.024154191212115*h1_1_vds - 1.997463228286444*h1_2_vds + 0.3957053892055906*h1_3_vds + 1.0662805851868935*h1_4_vds - 0.6247825032813225*h1_5_vds + 0.9742281394935626*h1_6_vds - 0.7162936763136747*h1_7_vds + 1.8306656275340027*h1_8_vds - 1.3204123886257413*h1_9_vds - 0.4546156159382238*h1_10_vds - 1.6883609260324741*h1_11_vds + 0.2851563780872549*h1_12_vds + 0.4103240621926418*h1_13_vds + 0.6190175732580496*h1_14_vds - 0.46870661031646266*h1_15_vds - 0.38361114024640103*h1_16_vds);
      h2_2_T = (1.0 - h2_2*h2_2)*(- 1.024154191212115*h1_1_T - 1.997463228286444*h1_2_T + 0.3957053892055906*h1_3_T + 1.0662805851868935*h1_4_T - 0.6247825032813225*h1_5_T + 0.9742281394935626*h1_6_T - 0.7162936763136747*h1_7_T + 1.8306656275340027*h1_8_T - 1.3204123886257413*h1_9_T - 0.4546156159382238*h1_10_T - 1.6883609260324741*h1_11_T + 0.2851563780872549*h1_12_T + 0.4103240621926418*h1_13_T + 0.6190175732580496*h1_14_T - 0.46870661031646266*h1_15_T - 0.38361114024640103*h1_16_T);
      h2_2_phi2 = (1.0 - h2_2*h2_2)*(- 1.024154191212115*h1_1_phi2 - 1.997463228286444*h1_2_phi2 + 0.3957053892055906*h1_3_phi2 + 1.0662805851868935*h1_4_phi2 - 0.6247825032813225*h1_5_phi2 + 0.9742281394935626*h1_6_phi2 - 0.7162936763136747*h1_7_phi2 + 1.8306656275340027*h1_8_phi2 - 1.3204123886257413*h1_9_phi2 - 0.4546156159382238*h1_10_phi2 - 1.6883609260324741*h1_11_phi2 + 0.2851563780872549*h1_12_phi2 + 0.4103240621926418*h1_13_phi2 + 0.6190175732580496*h1_14_phi2 - 0.46870661031646266*h1_15_phi2 - 0.38361114024640103*h1_16_phi2);
      z = -1.2267218288534267 + 0.6085508938778519*h1_1 + 0.4245461257075738*h1_2 + 0.20417347549453974*h1_3 + 0.23381963116964993*h1_4 + 0.46799059470395366*h1_5 + 0.6770350073393978*h1_6 - 0.1781095451384945*h1_7 - 0.5336965007490686*h1_8 + 0.43233005575978306*h1_9 + 0.3858716652324431*h1_10 + 0.5486548739037238*h1_11 - 0.12435465605359548*h1_12 - 0.20802459654117986*h1_13 - 0.3755511354673489*h1_14 + 0.31878913158868005*h1_15 + 0.37072743296992283*h1_16;
      h2_3 = tanh(z);
      h2_3_vgs = (1.0 - h2_3*h2_3)*(0.6085508938778519*h1_1_vgs + 0.4245461257075738*h1_2_vgs + 0.20417347549453974*h1_3_vgs + 0.23381963116964993*h1_4_vgs + 0.46799059470395366*h1_5_vgs + 0.6770350073393978*h1_6_vgs - 0.1781095451384945*h1_7_vgs - 0.5336965007490686*h1_8_vgs + 0.43233005575978306*h1_9_vgs + 0.3858716652324431*h1_10_vgs + 0.5486548739037238*h1_11_vgs - 0.12435465605359548*h1_12_vgs - 0.20802459654117986*h1_13_vgs - 0.3755511354673489*h1_14_vgs + 0.31878913158868005*h1_15_vgs + 0.37072743296992283*h1_16_vgs);
      h2_3_vds = (1.0 - h2_3*h2_3)*(0.6085508938778519*h1_1_vds + 0.4245461257075738*h1_2_vds + 0.20417347549453974*h1_3_vds + 0.23381963116964993*h1_4_vds + 0.46799059470395366*h1_5_vds + 0.6770350073393978*h1_6_vds - 0.1781095451384945*h1_7_vds - 0.5336965007490686*h1_8_vds + 0.43233005575978306*h1_9_vds + 0.3858716652324431*h1_10_vds + 0.5486548739037238*h1_11_vds - 0.12435465605359548*h1_12_vds - 0.20802459654117986*h1_13_vds - 0.3755511354673489*h1_14_vds + 0.31878913158868005*h1_15_vds + 0.37072743296992283*h1_16_vds);
      h2_3_T = (1.0 - h2_3*h2_3)*(0.6085508938778519*h1_1_T + 0.4245461257075738*h1_2_T + 0.20417347549453974*h1_3_T + 0.23381963116964993*h1_4_T + 0.46799059470395366*h1_5_T + 0.6770350073393978*h1_6_T - 0.1781095451384945*h1_7_T - 0.5336965007490686*h1_8_T + 0.43233005575978306*h1_9_T + 0.3858716652324431*h1_10_T + 0.5486548739037238*h1_11_T - 0.12435465605359548*h1_12_T - 0.20802459654117986*h1_13_T - 0.3755511354673489*h1_14_T + 0.31878913158868005*h1_15_T + 0.37072743296992283*h1_16_T);
      h2_3_phi2 = (1.0 - h2_3*h2_3)*(0.6085508938778519*h1_1_phi2 + 0.4245461257075738*h1_2_phi2 + 0.20417347549453974*h1_3_phi2 + 0.23381963116964993*h1_4_phi2 + 0.46799059470395366*h1_5_phi2 + 0.6770350073393978*h1_6_phi2 - 0.1781095451384945*h1_7_phi2 - 0.5336965007490686*h1_8_phi2 + 0.43233005575978306*h1_9_phi2 + 0.3858716652324431*h1_10_phi2 + 0.5486548739037238*h1_11_phi2 - 0.12435465605359548*h1_12_phi2 - 0.20802459654117986*h1_13_phi2 - 0.3755511354673489*h1_14_phi2 + 0.31878913158868005*h1_15_phi2 + 0.37072743296992283*h1_16_phi2);
      z = -0.25210960381712494 + 0.6579056893817751*h1_1 + 0.2487661059197458*h1_2 - 0.4522805582154707*h1_3 + 1.3728856447906856*h1_4 + 0.7343558023034248*h1_5 + 0.499951649288861*h1_6 + 1.5573179507447523*h1_7 - 1.2065241783238503*h1_8 + 0.8029225648683243*h1_9 - 0.39421995939934484*h1_10 + 0.4623783769287557*h1_11 - 0.4238567233745338*h1_12 + 0.11698660686858803*h1_13 - 0.6850773832669892*h1_14 + 0.42963631995037566*h1_15 - 0.10328740891248285*h1_16;
      h2_4 = tanh(z);
      h2_4_vgs = (1.0 - h2_4*h2_4)*(0.6579056893817751*h1_1_vgs + 0.2487661059197458*h1_2_vgs - 0.4522805582154707*h1_3_vgs + 1.3728856447906856*h1_4_vgs + 0.7343558023034248*h1_5_vgs + 0.499951649288861*h1_6_vgs + 1.5573179507447523*h1_7_vgs - 1.2065241783238503*h1_8_vgs + 0.8029225648683243*h1_9_vgs - 0.39421995939934484*h1_10_vgs + 0.4623783769287557*h1_11_vgs - 0.4238567233745338*h1_12_vgs + 0.11698660686858803*h1_13_vgs - 0.6850773832669892*h1_14_vgs + 0.42963631995037566*h1_15_vgs - 0.10328740891248285*h1_16_vgs);
      h2_4_vds = (1.0 - h2_4*h2_4)*(0.6579056893817751*h1_1_vds + 0.2487661059197458*h1_2_vds - 0.4522805582154707*h1_3_vds + 1.3728856447906856*h1_4_vds + 0.7343558023034248*h1_5_vds + 0.499951649288861*h1_6_vds + 1.5573179507447523*h1_7_vds - 1.2065241783238503*h1_8_vds + 0.8029225648683243*h1_9_vds - 0.39421995939934484*h1_10_vds + 0.4623783769287557*h1_11_vds - 0.4238567233745338*h1_12_vds + 0.11698660686858803*h1_13_vds - 0.6850773832669892*h1_14_vds + 0.42963631995037566*h1_15_vds - 0.10328740891248285*h1_16_vds);
      h2_4_T = (1.0 - h2_4*h2_4)*(0.6579056893817751*h1_1_T + 0.2487661059197458*h1_2_T - 0.4522805582154707*h1_3_T + 1.3728856447906856*h1_4_T + 0.7343558023034248*h1_5_T + 0.499951649288861*h1_6_T + 1.5573179507447523*h1_7_T - 1.2065241783238503*h1_8_T + 0.8029225648683243*h1_9_T - 0.39421995939934484*h1_10_T + 0.4623783769287557*h1_11_T - 0.4238567233745338*h1_12_T + 0.11698660686858803*h1_13_T - 0.6850773832669892*h1_14_T + 0.42963631995037566*h1_15_T - 0.10328740891248285*h1_16_T);
      h2_4_phi2 = (1.0 - h2_4*h2_4)*(0.6579056893817751*h1_1_phi2 + 0.2487661059197458*h1_2_phi2 - 0.4522805582154707*h1_3_phi2 + 1.3728856447906856*h1_4_phi2 + 0.7343558023034248*h1_5_phi2 + 0.499951649288861*h1_6_phi2 + 1.5573179507447523*h1_7_phi2 - 1.2065241783238503*h1_8_phi2 + 0.8029225648683243*h1_9_phi2 - 0.39421995939934484*h1_10_phi2 + 0.4623783769287557*h1_11_phi2 - 0.4238567233745338*h1_12_phi2 + 0.11698660686858803*h1_13_phi2 - 0.6850773832669892*h1_14_phi2 + 0.42963631995037566*h1_15_phi2 - 0.10328740891248285*h1_16_phi2);
      z = -0.12165235432908056 - 0.11347915461013727*h1_1 - 0.17375088955931245*h1_2 - 0.5679638613505028*h1_3 + 0.2127629915920271*h1_4 - 0.4088145631184316*h1_5 - 0.11822350661344289*h1_6 - 0.375230164265013*h1_7 - 0.3077837584079953*h1_8 - 0.3158985170451224*h1_9 - 0.46147102665334283*h1_10 + 0.6186444695178379*h1_11 + 0.05599310518032458*h1_12 - 0.36828556304922727*h1_13 - 0.06894965986716194*h1_14 - 0.31499715196455685*h1_15 - 0.18159716940206883*h1_16;
      h2_5 = tanh(z);
      h2_5_vgs = (1.0 - h2_5*h2_5)*(- 0.11347915461013727*h1_1_vgs - 0.17375088955931245*h1_2_vgs - 0.5679638613505028*h1_3_vgs + 0.2127629915920271*h1_4_vgs - 0.4088145631184316*h1_5_vgs - 0.11822350661344289*h1_6_vgs - 0.375230164265013*h1_7_vgs - 0.3077837584079953*h1_8_vgs - 0.3158985170451224*h1_9_vgs - 0.46147102665334283*h1_10_vgs + 0.6186444695178379*h1_11_vgs + 0.05599310518032458*h1_12_vgs - 0.36828556304922727*h1_13_vgs - 0.06894965986716194*h1_14_vgs - 0.31499715196455685*h1_15_vgs - 0.18159716940206883*h1_16_vgs);
      h2_5_vds = (1.0 - h2_5*h2_5)*(- 0.11347915461013727*h1_1_vds - 0.17375088955931245*h1_2_vds - 0.5679638613505028*h1_3_vds + 0.2127629915920271*h1_4_vds - 0.4088145631184316*h1_5_vds - 0.11822350661344289*h1_6_vds - 0.375230164265013*h1_7_vds - 0.3077837584079953*h1_8_vds - 0.3158985170451224*h1_9_vds - 0.46147102665334283*h1_10_vds + 0.6186444695178379*h1_11_vds + 0.05599310518032458*h1_12_vds - 0.36828556304922727*h1_13_vds - 0.06894965986716194*h1_14_vds - 0.31499715196455685*h1_15_vds - 0.18159716940206883*h1_16_vds);
      h2_5_T = (1.0 - h2_5*h2_5)*(- 0.11347915461013727*h1_1_T - 0.17375088955931245*h1_2_T - 0.5679638613505028*h1_3_T + 0.2127629915920271*h1_4_T - 0.4088145631184316*h1_5_T - 0.11822350661344289*h1_6_T - 0.375230164265013*h1_7_T - 0.3077837584079953*h1_8_T - 0.3158985170451224*h1_9_T - 0.46147102665334283*h1_10_T + 0.6186444695178379*h1_11_T + 0.05599310518032458*h1_12_T - 0.36828556304922727*h1_13_T - 0.06894965986716194*h1_14_T - 0.31499715196455685*h1_15_T - 0.18159716940206883*h1_16_T);
      h2_5_phi2 = (1.0 - h2_5*h2_5)*(- 0.11347915461013727*h1_1_phi2 - 0.17375088955931245*h1_2_phi2 - 0.5679638613505028*h1_3_phi2 + 0.2127629915920271*h1_4_phi2 - 0.4088145631184316*h1_5_phi2 - 0.11822350661344289*h1_6_phi2 - 0.375230164265013*h1_7_phi2 - 0.3077837584079953*h1_8_phi2 - 0.3158985170451224*h1_9_phi2 - 0.46147102665334283*h1_10_phi2 + 0.6186444695178379*h1_11_phi2 + 0.05599310518032458*h1_12_phi2 - 0.36828556304922727*h1_13_phi2 - 0.06894965986716194*h1_14_phi2 - 0.31499715196455685*h1_15_phi2 - 0.18159716940206883*h1_16_phi2);
      z = 1.3510581936010126 - 0.9205949626438599*h1_1 - 1.9585026660214784*h1_2 + 2.4946884292680616*h1_3 - 1.2800327551786954*h1_4 - 1.0046979545977028*h1_5 - 2.53106446022067*h1_6 - 0.04765625462776237*h1_7 + 2.0633147001164946*h1_8 + 0.747694945819464*h1_9 - 0.5570720644112932*h1_10 - 2.536185480606795*h1_11 + 0.6904309652180678*h1_12 - 0.6095747316312962*h1_13 - 0.2922216896617973*h1_14 - 0.13127122328220336*h1_15 + 0.06752497931821264*h1_16;
      h2_6 = tanh(z);
      h2_6_vgs = (1.0 - h2_6*h2_6)*(- 0.9205949626438599*h1_1_vgs - 1.9585026660214784*h1_2_vgs + 2.4946884292680616*h1_3_vgs - 1.2800327551786954*h1_4_vgs - 1.0046979545977028*h1_5_vgs - 2.53106446022067*h1_6_vgs - 0.04765625462776237*h1_7_vgs + 2.0633147001164946*h1_8_vgs + 0.747694945819464*h1_9_vgs - 0.5570720644112932*h1_10_vgs - 2.536185480606795*h1_11_vgs + 0.6904309652180678*h1_12_vgs - 0.6095747316312962*h1_13_vgs - 0.2922216896617973*h1_14_vgs - 0.13127122328220336*h1_15_vgs + 0.06752497931821264*h1_16_vgs);
      h2_6_vds = (1.0 - h2_6*h2_6)*(- 0.9205949626438599*h1_1_vds - 1.9585026660214784*h1_2_vds + 2.4946884292680616*h1_3_vds - 1.2800327551786954*h1_4_vds - 1.0046979545977028*h1_5_vds - 2.53106446022067*h1_6_vds - 0.04765625462776237*h1_7_vds + 2.0633147001164946*h1_8_vds + 0.747694945819464*h1_9_vds - 0.5570720644112932*h1_10_vds - 2.536185480606795*h1_11_vds + 0.6904309652180678*h1_12_vds - 0.6095747316312962*h1_13_vds - 0.2922216896617973*h1_14_vds - 0.13127122328220336*h1_15_vds + 0.06752497931821264*h1_16_vds);
      h2_6_T = (1.0 - h2_6*h2_6)*(- 0.9205949626438599*h1_1_T - 1.9585026660214784*h1_2_T + 2.4946884292680616*h1_3_T - 1.2800327551786954*h1_4_T - 1.0046979545977028*h1_5_T - 2.53106446022067*h1_6_T - 0.04765625462776237*h1_7_T + 2.0633147001164946*h1_8_T + 0.747694945819464*h1_9_T - 0.5570720644112932*h1_10_T - 2.536185480606795*h1_11_T + 0.6904309652180678*h1_12_T - 0.6095747316312962*h1_13_T - 0.2922216896617973*h1_14_T - 0.13127122328220336*h1_15_T + 0.06752497931821264*h1_16_T);
      h2_6_phi2 = (1.0 - h2_6*h2_6)*(- 0.9205949626438599*h1_1_phi2 - 1.9585026660214784*h1_2_phi2 + 2.4946884292680616*h1_3_phi2 - 1.2800327551786954*h1_4_phi2 - 1.0046979545977028*h1_5_phi2 - 2.53106446022067*h1_6_phi2 - 0.04765625462776237*h1_7_phi2 + 2.0633147001164946*h1_8_phi2 + 0.747694945819464*h1_9_phi2 - 0.5570720644112932*h1_10_phi2 - 2.536185480606795*h1_11_phi2 + 0.6904309652180678*h1_12_phi2 - 0.6095747316312962*h1_13_phi2 - 0.2922216896617973*h1_14_phi2 - 0.13127122328220336*h1_15_phi2 + 0.06752497931821264*h1_16_phi2);
      z = 0.30357106118408056 - 0.3389301451227669*h1_1 + 0.14954595600570916*h1_2 - 1.2858156088910961*h1_3 + 0.5789681568529786*h1_4 + 0.45037329403124604*h1_5 - 1.4470412823902208*h1_6 + 0.7305774506364213*h1_7 + 1.321030771436895*h1_8 - 3.1463721269878726*h1_9 - 0.30114990138708925*h1_10 - 1.1433981288901263*h1_11 + 1.350937889777977*h1_12 + 0.5055539893785143*h1_13 + 0.7610583285402289*h1_14 - 0.24024118266574848*h1_15 - 0.009247500136061166*h1_16;
      h2_7 = tanh(z);
      h2_7_vgs = (1.0 - h2_7*h2_7)*(- 0.3389301451227669*h1_1_vgs + 0.14954595600570916*h1_2_vgs - 1.2858156088910961*h1_3_vgs + 0.5789681568529786*h1_4_vgs + 0.45037329403124604*h1_5_vgs - 1.4470412823902208*h1_6_vgs + 0.7305774506364213*h1_7_vgs + 1.321030771436895*h1_8_vgs - 3.1463721269878726*h1_9_vgs - 0.30114990138708925*h1_10_vgs - 1.1433981288901263*h1_11_vgs + 1.350937889777977*h1_12_vgs + 0.5055539893785143*h1_13_vgs + 0.7610583285402289*h1_14_vgs - 0.24024118266574848*h1_15_vgs - 0.009247500136061166*h1_16_vgs);
      h2_7_vds = (1.0 - h2_7*h2_7)*(- 0.3389301451227669*h1_1_vds + 0.14954595600570916*h1_2_vds - 1.2858156088910961*h1_3_vds + 0.5789681568529786*h1_4_vds + 0.45037329403124604*h1_5_vds - 1.4470412823902208*h1_6_vds + 0.7305774506364213*h1_7_vds + 1.321030771436895*h1_8_vds - 3.1463721269878726*h1_9_vds - 0.30114990138708925*h1_10_vds - 1.1433981288901263*h1_11_vds + 1.350937889777977*h1_12_vds + 0.5055539893785143*h1_13_vds + 0.7610583285402289*h1_14_vds - 0.24024118266574848*h1_15_vds - 0.009247500136061166*h1_16_vds);
      h2_7_T = (1.0 - h2_7*h2_7)*(- 0.3389301451227669*h1_1_T + 0.14954595600570916*h1_2_T - 1.2858156088910961*h1_3_T + 0.5789681568529786*h1_4_T + 0.45037329403124604*h1_5_T - 1.4470412823902208*h1_6_T + 0.7305774506364213*h1_7_T + 1.321030771436895*h1_8_T - 3.1463721269878726*h1_9_T - 0.30114990138708925*h1_10_T - 1.1433981288901263*h1_11_T + 1.350937889777977*h1_12_T + 0.5055539893785143*h1_13_T + 0.7610583285402289*h1_14_T - 0.24024118266574848*h1_15_T - 0.009247500136061166*h1_16_T);
      h2_7_phi2 = (1.0 - h2_7*h2_7)*(- 0.3389301451227669*h1_1_phi2 + 0.14954595600570916*h1_2_phi2 - 1.2858156088910961*h1_3_phi2 + 0.5789681568529786*h1_4_phi2 + 0.45037329403124604*h1_5_phi2 - 1.4470412823902208*h1_6_phi2 + 0.7305774506364213*h1_7_phi2 + 1.321030771436895*h1_8_phi2 - 3.1463721269878726*h1_9_phi2 - 0.30114990138708925*h1_10_phi2 - 1.1433981288901263*h1_11_phi2 + 1.350937889777977*h1_12_phi2 + 0.5055539893785143*h1_13_phi2 + 0.7610583285402289*h1_14_phi2 - 0.24024118266574848*h1_15_phi2 - 0.009247500136061166*h1_16_phi2);
      z = -0.6713531978107528 + 0.3678787191439386*h1_1 + 0.21064799245213842*h1_2 + 0.9955128560489784*h1_3 + 1.6207924993577894*h1_4 + 1.0948829952766057*h1_5 + 1.7446456496709517*h1_6 + 1.4821596084878748*h1_7 - 1.2830262595106927*h1_8 + 2.8284202954114255*h1_9 + 1.4056622282576423*h1_10 + 0.5657495315053743*h1_11 - 0.4045897264193938*h1_12 - 0.339548225957459*h1_13 - 0.5754641833718283*h1_14 - 0.15961384616372742*h1_15 + 0.26381688243357015*h1_16;
      h2_8 = tanh(z);
      h2_8_vgs = (1.0 - h2_8*h2_8)*(0.3678787191439386*h1_1_vgs + 0.21064799245213842*h1_2_vgs + 0.9955128560489784*h1_3_vgs + 1.6207924993577894*h1_4_vgs + 1.0948829952766057*h1_5_vgs + 1.7446456496709517*h1_6_vgs + 1.4821596084878748*h1_7_vgs - 1.2830262595106927*h1_8_vgs + 2.8284202954114255*h1_9_vgs + 1.4056622282576423*h1_10_vgs + 0.5657495315053743*h1_11_vgs - 0.4045897264193938*h1_12_vgs - 0.339548225957459*h1_13_vgs - 0.5754641833718283*h1_14_vgs - 0.15961384616372742*h1_15_vgs + 0.26381688243357015*h1_16_vgs);
      h2_8_vds = (1.0 - h2_8*h2_8)*(0.3678787191439386*h1_1_vds + 0.21064799245213842*h1_2_vds + 0.9955128560489784*h1_3_vds + 1.6207924993577894*h1_4_vds + 1.0948829952766057*h1_5_vds + 1.7446456496709517*h1_6_vds + 1.4821596084878748*h1_7_vds - 1.2830262595106927*h1_8_vds + 2.8284202954114255*h1_9_vds + 1.4056622282576423*h1_10_vds + 0.5657495315053743*h1_11_vds - 0.4045897264193938*h1_12_vds - 0.339548225957459*h1_13_vds - 0.5754641833718283*h1_14_vds - 0.15961384616372742*h1_15_vds + 0.26381688243357015*h1_16_vds);
      h2_8_T = (1.0 - h2_8*h2_8)*(0.3678787191439386*h1_1_T + 0.21064799245213842*h1_2_T + 0.9955128560489784*h1_3_T + 1.6207924993577894*h1_4_T + 1.0948829952766057*h1_5_T + 1.7446456496709517*h1_6_T + 1.4821596084878748*h1_7_T - 1.2830262595106927*h1_8_T + 2.8284202954114255*h1_9_T + 1.4056622282576423*h1_10_T + 0.5657495315053743*h1_11_T - 0.4045897264193938*h1_12_T - 0.339548225957459*h1_13_T - 0.5754641833718283*h1_14_T - 0.15961384616372742*h1_15_T + 0.26381688243357015*h1_16_T);
      h2_8_phi2 = (1.0 - h2_8*h2_8)*(0.3678787191439386*h1_1_phi2 + 0.21064799245213842*h1_2_phi2 + 0.9955128560489784*h1_3_phi2 + 1.6207924993577894*h1_4_phi2 + 1.0948829952766057*h1_5_phi2 + 1.7446456496709517*h1_6_phi2 + 1.4821596084878748*h1_7_phi2 - 1.2830262595106927*h1_8_phi2 + 2.8284202954114255*h1_9_phi2 + 1.4056622282576423*h1_10_phi2 + 0.5657495315053743*h1_11_phi2 - 0.4045897264193938*h1_12_phi2 - 0.339548225957459*h1_13_phi2 - 0.5754641833718283*h1_14_phi2 - 0.15961384616372742*h1_15_phi2 + 0.26381688243357015*h1_16_phi2);
      z = -0.9208460518513691 + 0.2818051105187086*h1_1 - 0.05715331217333266*h1_2 + 0.3001842737357526*h1_3 + 0.3855871003233628*h1_4 + 0.3036008823484597*h1_5 + 0.4976987567234851*h1_6 + 0.14175363086438147*h1_7 - 0.23262011230490715*h1_8 + 0.17886512616943065*h1_9 + 0.1859392087631963*h1_10 + 1.0846106525727506*h1_11 - 0.16910583209334393*h1_12 - 0.3878179970549498*h1_13 - 0.45450846196106937*h1_14 - 0.030727547465622583*h1_15 - 0.18716424901839296*h1_16;
      h2_9 = tanh(z);
      h2_9_vgs = (1.0 - h2_9*h2_9)*(0.2818051105187086*h1_1_vgs - 0.05715331217333266*h1_2_vgs + 0.3001842737357526*h1_3_vgs + 0.3855871003233628*h1_4_vgs + 0.3036008823484597*h1_5_vgs + 0.4976987567234851*h1_6_vgs + 0.14175363086438147*h1_7_vgs - 0.23262011230490715*h1_8_vgs + 0.17886512616943065*h1_9_vgs + 0.1859392087631963*h1_10_vgs + 1.0846106525727506*h1_11_vgs - 0.16910583209334393*h1_12_vgs - 0.3878179970549498*h1_13_vgs - 0.45450846196106937*h1_14_vgs - 0.030727547465622583*h1_15_vgs - 0.18716424901839296*h1_16_vgs);
      h2_9_vds = (1.0 - h2_9*h2_9)*(0.2818051105187086*h1_1_vds - 0.05715331217333266*h1_2_vds + 0.3001842737357526*h1_3_vds + 0.3855871003233628*h1_4_vds + 0.3036008823484597*h1_5_vds + 0.4976987567234851*h1_6_vds + 0.14175363086438147*h1_7_vds - 0.23262011230490715*h1_8_vds + 0.17886512616943065*h1_9_vds + 0.1859392087631963*h1_10_vds + 1.0846106525727506*h1_11_vds - 0.16910583209334393*h1_12_vds - 0.3878179970549498*h1_13_vds - 0.45450846196106937*h1_14_vds - 0.030727547465622583*h1_15_vds - 0.18716424901839296*h1_16_vds);
      h2_9_T = (1.0 - h2_9*h2_9)*(0.2818051105187086*h1_1_T - 0.05715331217333266*h1_2_T + 0.3001842737357526*h1_3_T + 0.3855871003233628*h1_4_T + 0.3036008823484597*h1_5_T + 0.4976987567234851*h1_6_T + 0.14175363086438147*h1_7_T - 0.23262011230490715*h1_8_T + 0.17886512616943065*h1_9_T + 0.1859392087631963*h1_10_T + 1.0846106525727506*h1_11_T - 0.16910583209334393*h1_12_T - 0.3878179970549498*h1_13_T - 0.45450846196106937*h1_14_T - 0.030727547465622583*h1_15_T - 0.18716424901839296*h1_16_T);
      h2_9_phi2 = (1.0 - h2_9*h2_9)*(0.2818051105187086*h1_1_phi2 - 0.05715331217333266*h1_2_phi2 + 0.3001842737357526*h1_3_phi2 + 0.3855871003233628*h1_4_phi2 + 0.3036008823484597*h1_5_phi2 + 0.4976987567234851*h1_6_phi2 + 0.14175363086438147*h1_7_phi2 - 0.23262011230490715*h1_8_phi2 + 0.17886512616943065*h1_9_phi2 + 0.1859392087631963*h1_10_phi2 + 1.0846106525727506*h1_11_phi2 - 0.16910583209334393*h1_12_phi2 - 0.3878179970549498*h1_13_phi2 - 0.45450846196106937*h1_14_phi2 - 0.030727547465622583*h1_15_phi2 - 0.18716424901839296*h1_16_phi2);
      z = 0.46894371420368647 - 0.7451750317702179*h1_1 - 0.863154189842923*h1_2 - 0.7449976363448544*h1_3 - 1.0296890261682792*h1_4 - 0.48105814807115765*h1_5 - 0.27708788932171047*h1_6 - 1.2919404776583467*h1_7 + 0.9628669175628796*h1_8 - 1.9406058068714158*h1_9 - 1.2196696408338805*h1_10 - 0.4756493921606793*h1_11 + 1.0614407022536867*h1_12 - 0.09288705895857596*h1_13 + 1.1521703615680645*h1_14 + 0.534625096486643*h1_15 + 0.4237582870580184*h1_16;
      h2_10 = tanh(z);
      h2_10_vgs = (1.0 - h2_10*h2_10)*(- 0.7451750317702179*h1_1_vgs - 0.863154189842923*h1_2_vgs - 0.7449976363448544*h1_3_vgs - 1.0296890261682792*h1_4_vgs - 0.48105814807115765*h1_5_vgs - 0.27708788932171047*h1_6_vgs - 1.2919404776583467*h1_7_vgs + 0.9628669175628796*h1_8_vgs - 1.9406058068714158*h1_9_vgs - 1.2196696408338805*h1_10_vgs - 0.4756493921606793*h1_11_vgs + 1.0614407022536867*h1_12_vgs - 0.09288705895857596*h1_13_vgs + 1.1521703615680645*h1_14_vgs + 0.534625096486643*h1_15_vgs + 0.4237582870580184*h1_16_vgs);
      h2_10_vds = (1.0 - h2_10*h2_10)*(- 0.7451750317702179*h1_1_vds - 0.863154189842923*h1_2_vds - 0.7449976363448544*h1_3_vds - 1.0296890261682792*h1_4_vds - 0.48105814807115765*h1_5_vds - 0.27708788932171047*h1_6_vds - 1.2919404776583467*h1_7_vds + 0.9628669175628796*h1_8_vds - 1.9406058068714158*h1_9_vds - 1.2196696408338805*h1_10_vds - 0.4756493921606793*h1_11_vds + 1.0614407022536867*h1_12_vds - 0.09288705895857596*h1_13_vds + 1.1521703615680645*h1_14_vds + 0.534625096486643*h1_15_vds + 0.4237582870580184*h1_16_vds);
      h2_10_T = (1.0 - h2_10*h2_10)*(- 0.7451750317702179*h1_1_T - 0.863154189842923*h1_2_T - 0.7449976363448544*h1_3_T - 1.0296890261682792*h1_4_T - 0.48105814807115765*h1_5_T - 0.27708788932171047*h1_6_T - 1.2919404776583467*h1_7_T + 0.9628669175628796*h1_8_T - 1.9406058068714158*h1_9_T - 1.2196696408338805*h1_10_T - 0.4756493921606793*h1_11_T + 1.0614407022536867*h1_12_T - 0.09288705895857596*h1_13_T + 1.1521703615680645*h1_14_T + 0.534625096486643*h1_15_T + 0.4237582870580184*h1_16_T);
      h2_10_phi2 = (1.0 - h2_10*h2_10)*(- 0.7451750317702179*h1_1_phi2 - 0.863154189842923*h1_2_phi2 - 0.7449976363448544*h1_3_phi2 - 1.0296890261682792*h1_4_phi2 - 0.48105814807115765*h1_5_phi2 - 0.27708788932171047*h1_6_phi2 - 1.2919404776583467*h1_7_phi2 + 0.9628669175628796*h1_8_phi2 - 1.9406058068714158*h1_9_phi2 - 1.2196696408338805*h1_10_phi2 - 0.4756493921606793*h1_11_phi2 + 1.0614407022536867*h1_12_phi2 - 0.09288705895857596*h1_13_phi2 + 1.1521703615680645*h1_14_phi2 + 0.534625096486643*h1_15_phi2 + 0.4237582870580184*h1_16_phi2);
      z = -0.6347594503317892 + 0.23713807123220237*h1_1 + 0.5645141607847142*h1_2 + 0.4882400424016057*h1_3 + 0.7199592630714079*h1_4 + 0.6458084657630576*h1_5 + 0.11651498999677508*h1_6 + 0.1995502559285629*h1_7 - 0.3635106023486677*h1_8 - 0.029170776301687143*h1_9 + 0.4750755727949535*h1_10 + 0.400977766807804*h1_11 - 0.2566040023635934*h1_12 - 0.20446687784122375*h1_13 + 0.02847910989320457*h1_14 + 0.2038129770815618*h1_15 + 0.2063313296019467*h1_16;
      h2_11 = tanh(z);
      h2_11_vgs = (1.0 - h2_11*h2_11)*(0.23713807123220237*h1_1_vgs + 0.5645141607847142*h1_2_vgs + 0.4882400424016057*h1_3_vgs + 0.7199592630714079*h1_4_vgs + 0.6458084657630576*h1_5_vgs + 0.11651498999677508*h1_6_vgs + 0.1995502559285629*h1_7_vgs - 0.3635106023486677*h1_8_vgs - 0.029170776301687143*h1_9_vgs + 0.4750755727949535*h1_10_vgs + 0.400977766807804*h1_11_vgs - 0.2566040023635934*h1_12_vgs - 0.20446687784122375*h1_13_vgs + 0.02847910989320457*h1_14_vgs + 0.2038129770815618*h1_15_vgs + 0.2063313296019467*h1_16_vgs);
      h2_11_vds = (1.0 - h2_11*h2_11)*(0.23713807123220237*h1_1_vds + 0.5645141607847142*h1_2_vds + 0.4882400424016057*h1_3_vds + 0.7199592630714079*h1_4_vds + 0.6458084657630576*h1_5_vds + 0.11651498999677508*h1_6_vds + 0.1995502559285629*h1_7_vds - 0.3635106023486677*h1_8_vds - 0.029170776301687143*h1_9_vds + 0.4750755727949535*h1_10_vds + 0.400977766807804*h1_11_vds - 0.2566040023635934*h1_12_vds - 0.20446687784122375*h1_13_vds + 0.02847910989320457*h1_14_vds + 0.2038129770815618*h1_15_vds + 0.2063313296019467*h1_16_vds);
      h2_11_T = (1.0 - h2_11*h2_11)*(0.23713807123220237*h1_1_T + 0.5645141607847142*h1_2_T + 0.4882400424016057*h1_3_T + 0.7199592630714079*h1_4_T + 0.6458084657630576*h1_5_T + 0.11651498999677508*h1_6_T + 0.1995502559285629*h1_7_T - 0.3635106023486677*h1_8_T - 0.029170776301687143*h1_9_T + 0.4750755727949535*h1_10_T + 0.400977766807804*h1_11_T - 0.2566040023635934*h1_12_T - 0.20446687784122375*h1_13_T + 0.02847910989320457*h1_14_T + 0.2038129770815618*h1_15_T + 0.2063313296019467*h1_16_T);
      h2_11_phi2 = (1.0 - h2_11*h2_11)*(0.23713807123220237*h1_1_phi2 + 0.5645141607847142*h1_2_phi2 + 0.4882400424016057*h1_3_phi2 + 0.7199592630714079*h1_4_phi2 + 0.6458084657630576*h1_5_phi2 + 0.11651498999677508*h1_6_phi2 + 0.1995502559285629*h1_7_phi2 - 0.3635106023486677*h1_8_phi2 - 0.029170776301687143*h1_9_phi2 + 0.4750755727949535*h1_10_phi2 + 0.400977766807804*h1_11_phi2 - 0.2566040023635934*h1_12_phi2 - 0.20446687784122375*h1_13_phi2 + 0.02847910989320457*h1_14_phi2 + 0.2038129770815618*h1_15_phi2 + 0.2063313296019467*h1_16_phi2);
      z = -0.05640801609008649 + 0.49183857381321416*h1_1 + 0.04048112053991444*h1_2 - 0.5225967248271675*h1_3 - 0.5755019028215873*h1_4 + 0.4542139917747501*h1_5 - 0.23223409664175773*h1_6 + 0.6704991563385696*h1_7 - 0.14806698382190733*h1_8 + 0.24402588709045764*h1_9 - 0.1191959413733128*h1_10 + 0.26336754019523495*h1_11 - 2.437129351205779*h1_12 - 0.15531757796583603*h1_13 - 0.363526035361489*h1_14 + 0.17195553402667468*h1_15 - 0.036029155096377635*h1_16;
      h2_12 = tanh(z);
      h2_12_vgs = (1.0 - h2_12*h2_12)*(0.49183857381321416*h1_1_vgs + 0.04048112053991444*h1_2_vgs - 0.5225967248271675*h1_3_vgs - 0.5755019028215873*h1_4_vgs + 0.4542139917747501*h1_5_vgs - 0.23223409664175773*h1_6_vgs + 0.6704991563385696*h1_7_vgs - 0.14806698382190733*h1_8_vgs + 0.24402588709045764*h1_9_vgs - 0.1191959413733128*h1_10_vgs + 0.26336754019523495*h1_11_vgs - 2.437129351205779*h1_12_vgs - 0.15531757796583603*h1_13_vgs - 0.363526035361489*h1_14_vgs + 0.17195553402667468*h1_15_vgs - 0.036029155096377635*h1_16_vgs);
      h2_12_vds = (1.0 - h2_12*h2_12)*(0.49183857381321416*h1_1_vds + 0.04048112053991444*h1_2_vds - 0.5225967248271675*h1_3_vds - 0.5755019028215873*h1_4_vds + 0.4542139917747501*h1_5_vds - 0.23223409664175773*h1_6_vds + 0.6704991563385696*h1_7_vds - 0.14806698382190733*h1_8_vds + 0.24402588709045764*h1_9_vds - 0.1191959413733128*h1_10_vds + 0.26336754019523495*h1_11_vds - 2.437129351205779*h1_12_vds - 0.15531757796583603*h1_13_vds - 0.363526035361489*h1_14_vds + 0.17195553402667468*h1_15_vds - 0.036029155096377635*h1_16_vds);
      h2_12_T = (1.0 - h2_12*h2_12)*(0.49183857381321416*h1_1_T + 0.04048112053991444*h1_2_T - 0.5225967248271675*h1_3_T - 0.5755019028215873*h1_4_T + 0.4542139917747501*h1_5_T - 0.23223409664175773*h1_6_T + 0.6704991563385696*h1_7_T - 0.14806698382190733*h1_8_T + 0.24402588709045764*h1_9_T - 0.1191959413733128*h1_10_T + 0.26336754019523495*h1_11_T - 2.437129351205779*h1_12_T - 0.15531757796583603*h1_13_T - 0.363526035361489*h1_14_T + 0.17195553402667468*h1_15_T - 0.036029155096377635*h1_16_T);
      h2_12_phi2 = (1.0 - h2_12*h2_12)*(0.49183857381321416*h1_1_phi2 + 0.04048112053991444*h1_2_phi2 - 0.5225967248271675*h1_3_phi2 - 0.5755019028215873*h1_4_phi2 + 0.4542139917747501*h1_5_phi2 - 0.23223409664175773*h1_6_phi2 + 0.6704991563385696*h1_7_phi2 - 0.14806698382190733*h1_8_phi2 + 0.24402588709045764*h1_9_phi2 - 0.1191959413733128*h1_10_phi2 + 0.26336754019523495*h1_11_phi2 - 2.437129351205779*h1_12_phi2 - 0.15531757796583603*h1_13_phi2 - 0.363526035361489*h1_14_phi2 + 0.17195553402667468*h1_15_phi2 - 0.036029155096377635*h1_16_phi2);
      z = -1.1842190401042925 + 1.0493002345573068*h1_1 - 0.007537331504496679*h1_2 + 0.12431196569915957*h1_3 - 0.44744069800557174*h1_4 + 0.6104138779460188*h1_5 + 0.016005066161728226*h1_6 + 1.223875226602172*h1_7 + 0.01911136650846021*h1_8 + 0.027867029674570186*h1_9 + 0.0563311663953799*h1_10 + 0.32761463163098736*h1_11 - 1.8713683647639283*h1_12 - 0.1879007237586718*h1_13 + 0.2799525023325937*h1_14 - 0.8592302264029971*h1_15 - 0.5465242417831755*h1_16;
      h2_13 = tanh(z);
      h2_13_vgs = (1.0 - h2_13*h2_13)*(1.0493002345573068*h1_1_vgs - 0.007537331504496679*h1_2_vgs + 0.12431196569915957*h1_3_vgs - 0.44744069800557174*h1_4_vgs + 0.6104138779460188*h1_5_vgs + 0.016005066161728226*h1_6_vgs + 1.223875226602172*h1_7_vgs + 0.01911136650846021*h1_8_vgs + 0.027867029674570186*h1_9_vgs + 0.0563311663953799*h1_10_vgs + 0.32761463163098736*h1_11_vgs - 1.8713683647639283*h1_12_vgs - 0.1879007237586718*h1_13_vgs + 0.2799525023325937*h1_14_vgs - 0.8592302264029971*h1_15_vgs - 0.5465242417831755*h1_16_vgs);
      h2_13_vds = (1.0 - h2_13*h2_13)*(1.0493002345573068*h1_1_vds - 0.007537331504496679*h1_2_vds + 0.12431196569915957*h1_3_vds - 0.44744069800557174*h1_4_vds + 0.6104138779460188*h1_5_vds + 0.016005066161728226*h1_6_vds + 1.223875226602172*h1_7_vds + 0.01911136650846021*h1_8_vds + 0.027867029674570186*h1_9_vds + 0.0563311663953799*h1_10_vds + 0.32761463163098736*h1_11_vds - 1.8713683647639283*h1_12_vds - 0.1879007237586718*h1_13_vds + 0.2799525023325937*h1_14_vds - 0.8592302264029971*h1_15_vds - 0.5465242417831755*h1_16_vds);
      h2_13_T = (1.0 - h2_13*h2_13)*(1.0493002345573068*h1_1_T - 0.007537331504496679*h1_2_T + 0.12431196569915957*h1_3_T - 0.44744069800557174*h1_4_T + 0.6104138779460188*h1_5_T + 0.016005066161728226*h1_6_T + 1.223875226602172*h1_7_T + 0.01911136650846021*h1_8_T + 0.027867029674570186*h1_9_T + 0.0563311663953799*h1_10_T + 0.32761463163098736*h1_11_T - 1.8713683647639283*h1_12_T - 0.1879007237586718*h1_13_T + 0.2799525023325937*h1_14_T - 0.8592302264029971*h1_15_T - 0.5465242417831755*h1_16_T);
      h2_13_phi2 = (1.0 - h2_13*h2_13)*(1.0493002345573068*h1_1_phi2 - 0.007537331504496679*h1_2_phi2 + 0.12431196569915957*h1_3_phi2 - 0.44744069800557174*h1_4_phi2 + 0.6104138779460188*h1_5_phi2 + 0.016005066161728226*h1_6_phi2 + 1.223875226602172*h1_7_phi2 + 0.01911136650846021*h1_8_phi2 + 0.027867029674570186*h1_9_phi2 + 0.0563311663953799*h1_10_phi2 + 0.32761463163098736*h1_11_phi2 - 1.8713683647639283*h1_12_phi2 - 0.1879007237586718*h1_13_phi2 + 0.2799525023325937*h1_14_phi2 - 0.8592302264029971*h1_15_phi2 - 0.5465242417831755*h1_16_phi2);
      z = -0.7547773359407911 + 0.3942853276899113*h1_1 + 0.4779450834689654*h1_2 - 0.24999434082663782*h1_3 + 0.1822172911069519*h1_4 + 0.5077702340117999*h1_5 + 0.299991208971705*h1_6 + 0.545428428417858*h1_7 - 0.138218589568305*h1_8 + 0.06846694277352341*h1_9 + 0.2991435760902639*h1_10 + 0.4192191497900634*h1_11 - 0.7294967336673598*h1_12 + 0.18034516282352508*h1_13 + 0.0350886634411704*h1_14 + 0.11988291323190602*h1_15 + 0.04970304423139534*h1_16;
      h2_14 = tanh(z);
      h2_14_vgs = (1.0 - h2_14*h2_14)*(0.3942853276899113*h1_1_vgs + 0.4779450834689654*h1_2_vgs - 0.24999434082663782*h1_3_vgs + 0.1822172911069519*h1_4_vgs + 0.5077702340117999*h1_5_vgs + 0.299991208971705*h1_6_vgs + 0.545428428417858*h1_7_vgs - 0.138218589568305*h1_8_vgs + 0.06846694277352341*h1_9_vgs + 0.2991435760902639*h1_10_vgs + 0.4192191497900634*h1_11_vgs - 0.7294967336673598*h1_12_vgs + 0.18034516282352508*h1_13_vgs + 0.0350886634411704*h1_14_vgs + 0.11988291323190602*h1_15_vgs + 0.04970304423139534*h1_16_vgs);
      h2_14_vds = (1.0 - h2_14*h2_14)*(0.3942853276899113*h1_1_vds + 0.4779450834689654*h1_2_vds - 0.24999434082663782*h1_3_vds + 0.1822172911069519*h1_4_vds + 0.5077702340117999*h1_5_vds + 0.299991208971705*h1_6_vds + 0.545428428417858*h1_7_vds - 0.138218589568305*h1_8_vds + 0.06846694277352341*h1_9_vds + 0.2991435760902639*h1_10_vds + 0.4192191497900634*h1_11_vds - 0.7294967336673598*h1_12_vds + 0.18034516282352508*h1_13_vds + 0.0350886634411704*h1_14_vds + 0.11988291323190602*h1_15_vds + 0.04970304423139534*h1_16_vds);
      h2_14_T = (1.0 - h2_14*h2_14)*(0.3942853276899113*h1_1_T + 0.4779450834689654*h1_2_T - 0.24999434082663782*h1_3_T + 0.1822172911069519*h1_4_T + 0.5077702340117999*h1_5_T + 0.299991208971705*h1_6_T + 0.545428428417858*h1_7_T - 0.138218589568305*h1_8_T + 0.06846694277352341*h1_9_T + 0.2991435760902639*h1_10_T + 0.4192191497900634*h1_11_T - 0.7294967336673598*h1_12_T + 0.18034516282352508*h1_13_T + 0.0350886634411704*h1_14_T + 0.11988291323190602*h1_15_T + 0.04970304423139534*h1_16_T);
      h2_14_phi2 = (1.0 - h2_14*h2_14)*(0.3942853276899113*h1_1_phi2 + 0.4779450834689654*h1_2_phi2 - 0.24999434082663782*h1_3_phi2 + 0.1822172911069519*h1_4_phi2 + 0.5077702340117999*h1_5_phi2 + 0.299991208971705*h1_6_phi2 + 0.545428428417858*h1_7_phi2 - 0.138218589568305*h1_8_phi2 + 0.06846694277352341*h1_9_phi2 + 0.2991435760902639*h1_10_phi2 + 0.4192191497900634*h1_11_phi2 - 0.7294967336673598*h1_12_phi2 + 0.18034516282352508*h1_13_phi2 + 0.0350886634411704*h1_14_phi2 + 0.11988291323190602*h1_15_phi2 + 0.04970304423139534*h1_16_phi2);
      z = 0.9012579869744747 - 0.26818746791499304*h1_1 - 0.18007576732349245*h1_2 - 0.011561865194354789*h1_3 - 0.19271887573332633*h1_4 - 0.4965032712055359*h1_5 - 0.5602551756364744*h1_6 - 0.07762362170472208*h1_7 + 0.7809732362807579*h1_8 - 0.3715573220608006*h1_9 - 0.031722312050862414*h1_10 - 0.30567063818986767*h1_11 + 0.130281609222736*h1_12 + 0.17742056045748134*h1_13 + 0.3094442213223849*h1_14 - 0.27886228105910266*h1_15 - 0.2112010456416726*h1_16;
      h2_15 = tanh(z);
      h2_15_vgs = (1.0 - h2_15*h2_15)*(- 0.26818746791499304*h1_1_vgs - 0.18007576732349245*h1_2_vgs - 0.011561865194354789*h1_3_vgs - 0.19271887573332633*h1_4_vgs - 0.4965032712055359*h1_5_vgs - 0.5602551756364744*h1_6_vgs - 0.07762362170472208*h1_7_vgs + 0.7809732362807579*h1_8_vgs - 0.3715573220608006*h1_9_vgs - 0.031722312050862414*h1_10_vgs - 0.30567063818986767*h1_11_vgs + 0.130281609222736*h1_12_vgs + 0.17742056045748134*h1_13_vgs + 0.3094442213223849*h1_14_vgs - 0.27886228105910266*h1_15_vgs - 0.2112010456416726*h1_16_vgs);
      h2_15_vds = (1.0 - h2_15*h2_15)*(- 0.26818746791499304*h1_1_vds - 0.18007576732349245*h1_2_vds - 0.011561865194354789*h1_3_vds - 0.19271887573332633*h1_4_vds - 0.4965032712055359*h1_5_vds - 0.5602551756364744*h1_6_vds - 0.07762362170472208*h1_7_vds + 0.7809732362807579*h1_8_vds - 0.3715573220608006*h1_9_vds - 0.031722312050862414*h1_10_vds - 0.30567063818986767*h1_11_vds + 0.130281609222736*h1_12_vds + 0.17742056045748134*h1_13_vds + 0.3094442213223849*h1_14_vds - 0.27886228105910266*h1_15_vds - 0.2112010456416726*h1_16_vds);
      h2_15_T = (1.0 - h2_15*h2_15)*(- 0.26818746791499304*h1_1_T - 0.18007576732349245*h1_2_T - 0.011561865194354789*h1_3_T - 0.19271887573332633*h1_4_T - 0.4965032712055359*h1_5_T - 0.5602551756364744*h1_6_T - 0.07762362170472208*h1_7_T + 0.7809732362807579*h1_8_T - 0.3715573220608006*h1_9_T - 0.031722312050862414*h1_10_T - 0.30567063818986767*h1_11_T + 0.130281609222736*h1_12_T + 0.17742056045748134*h1_13_T + 0.3094442213223849*h1_14_T - 0.27886228105910266*h1_15_T - 0.2112010456416726*h1_16_T);
      h2_15_phi2 = (1.0 - h2_15*h2_15)*(- 0.26818746791499304*h1_1_phi2 - 0.18007576732349245*h1_2_phi2 - 0.011561865194354789*h1_3_phi2 - 0.19271887573332633*h1_4_phi2 - 0.4965032712055359*h1_5_phi2 - 0.5602551756364744*h1_6_phi2 - 0.07762362170472208*h1_7_phi2 + 0.7809732362807579*h1_8_phi2 - 0.3715573220608006*h1_9_phi2 - 0.031722312050862414*h1_10_phi2 - 0.30567063818986767*h1_11_phi2 + 0.130281609222736*h1_12_phi2 + 0.17742056045748134*h1_13_phi2 + 0.3094442213223849*h1_14_phi2 - 0.27886228105910266*h1_15_phi2 - 0.2112010456416726*h1_16_phi2);
      z = 1.2256879072231737 + 0.008635895763493022*h1_1 - 2.1330351827739724*h1_2 + 0.31989572262462934*h1_3 - 0.36935238207795085*h1_4 - 0.6933459324686571*h1_5 - 2.5046993879989015*h1_6 + 0.19530121139615478*h1_7 + 0.6933847288408136*h1_8 - 0.4689711958075527*h1_9 - 1.6134716049556732*h1_10 - 0.39083278097699*h1_11 + 1.0482869449274397*h1_12 + 0.2865126306130431*h1_13 - 0.6596181482638354*h1_14 - 0.809443434068489*h1_15 - 0.4888975192708755*h1_16;
      h2_16 = tanh(z);
      h2_16_vgs = (1.0 - h2_16*h2_16)*(0.008635895763493022*h1_1_vgs - 2.1330351827739724*h1_2_vgs + 0.31989572262462934*h1_3_vgs - 0.36935238207795085*h1_4_vgs - 0.6933459324686571*h1_5_vgs - 2.5046993879989015*h1_6_vgs + 0.19530121139615478*h1_7_vgs + 0.6933847288408136*h1_8_vgs - 0.4689711958075527*h1_9_vgs - 1.6134716049556732*h1_10_vgs - 0.39083278097699*h1_11_vgs + 1.0482869449274397*h1_12_vgs + 0.2865126306130431*h1_13_vgs - 0.6596181482638354*h1_14_vgs - 0.809443434068489*h1_15_vgs - 0.4888975192708755*h1_16_vgs);
      h2_16_vds = (1.0 - h2_16*h2_16)*(0.008635895763493022*h1_1_vds - 2.1330351827739724*h1_2_vds + 0.31989572262462934*h1_3_vds - 0.36935238207795085*h1_4_vds - 0.6933459324686571*h1_5_vds - 2.5046993879989015*h1_6_vds + 0.19530121139615478*h1_7_vds + 0.6933847288408136*h1_8_vds - 0.4689711958075527*h1_9_vds - 1.6134716049556732*h1_10_vds - 0.39083278097699*h1_11_vds + 1.0482869449274397*h1_12_vds + 0.2865126306130431*h1_13_vds - 0.6596181482638354*h1_14_vds - 0.809443434068489*h1_15_vds - 0.4888975192708755*h1_16_vds);
      h2_16_T = (1.0 - h2_16*h2_16)*(0.008635895763493022*h1_1_T - 2.1330351827739724*h1_2_T + 0.31989572262462934*h1_3_T - 0.36935238207795085*h1_4_T - 0.6933459324686571*h1_5_T - 2.5046993879989015*h1_6_T + 0.19530121139615478*h1_7_T + 0.6933847288408136*h1_8_T - 0.4689711958075527*h1_9_T - 1.6134716049556732*h1_10_T - 0.39083278097699*h1_11_T + 1.0482869449274397*h1_12_T + 0.2865126306130431*h1_13_T - 0.6596181482638354*h1_14_T - 0.809443434068489*h1_15_T - 0.4888975192708755*h1_16_T);
      h2_16_phi2 = (1.0 - h2_16*h2_16)*(0.008635895763493022*h1_1_phi2 - 2.1330351827739724*h1_2_phi2 + 0.31989572262462934*h1_3_phi2 - 0.36935238207795085*h1_4_phi2 - 0.6933459324686571*h1_5_phi2 - 2.5046993879989015*h1_6_phi2 + 0.19530121139615478*h1_7_phi2 + 0.6933847288408136*h1_8_phi2 - 0.4689711958075527*h1_9_phi2 - 1.6134716049556732*h1_10_phi2 - 0.39083278097699*h1_11_phi2 + 1.0482869449274397*h1_12_phi2 + 0.2865126306130431*h1_13_phi2 - 0.6596181482638354*h1_14_phi2 - 0.809443434068489*h1_15_phi2 - 0.4888975192708755*h1_16_phi2);
      // output
      u = -2.6564552951971954 - 0.5883570145555063*h2_1 + 1.7457239286124295*h2_2 + 0.4863867300911194*h2_3 - 1.0929992780415518*h2_4 + 0.0026785243770998976*h2_5 - 2.732012792049836*h2_6 + 3.5798625572772726*h2_7 - 2.421221073683618*h2_8 + 1.1377740457512557*h2_9 + 2.2258803554908004*h2_10 - 0.1851954134993682*h2_11 - 0.025417153929914924*h2_12 + 2.328472589060345*h2_13 + 0.016528925190449413*h2_14 + 0.09671966818049069*h2_15 - 2.1432067673907813*h2_16;
      u_vgs = - 0.5883570145555063*h2_1_vgs + 1.7457239286124295*h2_2_vgs + 0.4863867300911194*h2_3_vgs - 1.0929992780415518*h2_4_vgs + 0.0026785243770998976*h2_5_vgs - 2.732012792049836*h2_6_vgs + 3.5798625572772726*h2_7_vgs - 2.421221073683618*h2_8_vgs + 1.1377740457512557*h2_9_vgs + 2.2258803554908004*h2_10_vgs - 0.1851954134993682*h2_11_vgs - 0.025417153929914924*h2_12_vgs + 2.328472589060345*h2_13_vgs + 0.016528925190449413*h2_14_vgs + 0.09671966818049069*h2_15_vgs - 2.1432067673907813*h2_16_vgs;
      u_vds = - 0.5883570145555063*h2_1_vds + 1.7457239286124295*h2_2_vds + 0.4863867300911194*h2_3_vds - 1.0929992780415518*h2_4_vds + 0.0026785243770998976*h2_5_vds - 2.732012792049836*h2_6_vds + 3.5798625572772726*h2_7_vds - 2.421221073683618*h2_8_vds + 1.1377740457512557*h2_9_vds + 2.2258803554908004*h2_10_vds - 0.1851954134993682*h2_11_vds - 0.025417153929914924*h2_12_vds + 2.328472589060345*h2_13_vds + 0.016528925190449413*h2_14_vds + 0.09671966818049069*h2_15_vds - 2.1432067673907813*h2_16_vds;
      u_T = - 0.5883570145555063*h2_1_T + 1.7457239286124295*h2_2_T + 0.4863867300911194*h2_3_T - 1.0929992780415518*h2_4_T + 0.0026785243770998976*h2_5_T - 2.732012792049836*h2_6_T + 3.5798625572772726*h2_7_T - 2.421221073683618*h2_8_T + 1.1377740457512557*h2_9_T + 2.2258803554908004*h2_10_T - 0.1851954134993682*h2_11_T - 0.025417153929914924*h2_12_T + 2.328472589060345*h2_13_T + 0.016528925190449413*h2_14_T + 0.09671966818049069*h2_15_T - 2.1432067673907813*h2_16_T;
      u_phi2 = - 0.5883570145555063*h2_1_phi2 + 1.7457239286124295*h2_2_phi2 + 0.4863867300911194*h2_3_phi2 - 1.0929992780415518*h2_4_phi2 + 0.0026785243770998976*h2_5_phi2 - 2.732012792049836*h2_6_phi2 + 3.5798625572772726*h2_7_phi2 - 2.421221073683618*h2_8_phi2 + 1.1377740457512557*h2_9_phi2 + 2.2258803554908004*h2_10_phi2 - 0.1851954134993682*h2_11_phi2 - 0.025417153929914924*h2_12_phi2 + 2.328472589060345*h2_13_phi2 + 0.016528925190449413*h2_14_phi2 + 0.09671966818049069*h2_15_phi2 - 2.1432067673907813*h2_16_phi2;
      f_Id = 0.065463901245 + 0.091502068855*u;
      d_vgs = 0.091502068855*u_vgs;
      d_vds = 0.091502068855*u_vds;
      d_T = 0.091502068855*u_T;
      d_phi2 = 0.091502068855*u_phi2;
    end
  endfunction

  // Core.Constituents.Id.Network continued outside Core.Constituents.Id.Domain (guided extrapolation)
  analog function real x_Id;
    input vgs, vds, T, phi2;
    real vgs, vds, T, phi2;
    real u_vgs, u_vds, u_T, u_phi2, b_vgs, b_vds, b_T, b_phi2, p_vgs, p_vds, p_T, p_phi2;
    real g_vgs, g_vds, g_T, g_phi2, t, cx, cy, e, best, cr, fb, s;
    real dist2, gl, ga;
    integer inside, inbox;
    begin
      // normalised by the domain's centre and extent
      u_vgs = (vgs - (-2.075844497250043))/5.848311005851915;
      u_vds = (vds - 9.999999999453182)/19.99999999902244;
      u_T = (T - 75.0)/100.0;
      u_phi2 = (phi2 - 9.9999999999008)/19.999999999830397;
      inbox = 1;
      // Domain.Box.T
      if (u_T < (-0.5)) begin b_T = (-0.5); inbox = 0; end
      else if (u_T > 0.5) begin b_T = 0.5; inbox = 0; end
      else b_T = u_T;
      // Domain.Box.phi2
      if (u_phi2 < (-0.5)) begin b_phi2 = (-0.5); inbox = 0; end
      else if (u_phi2 > 0.5) begin b_phi2 = 0.5; inbox = 0; end
      else b_phi2 = u_phi2;
      // Domain.Polygon: 27 vertices, counter-clockwise
      inside = 1;
      cr = 1.3542333920923966e-11*(u_vds - 0.49999999999999967) - (-0.19999999999845564)*(u_vgs - (-0.5));
      if (cr < 0.0) inside = 0;
      cr = 3.3856029091339224e-11*(u_vds - 0.30000000000154403) - (-0.49999999999613887)*(u_vgs - (-0.49999999998645767));
      if (cr < 0.0) inside = 0;
      cr = 1.6928125567972074e-11*(u_vds - (-0.19999999999459486)) - (-0.2499999999980694)*(u_vgs - (-0.49999999995260164));
      if (cr < 0.0) inside = 0;
      cr = 1.6928680679484387e-12*(u_vds - (-0.44999999999266427)) - (-0.0249999999998069)*(u_vgs - (-0.4999999999356735));
      if (cr < 0.0) inside = 0;
      cr = 4.2935932587084835e-10*(u_vds - (-0.47499999999247117)) - (-0.025000000007528833)*(u_vgs - (-0.49999999993398064));
      if (cr < 0.0) inside = 0;
      cr = 0.9233435074941116*(u_vds - (-0.5)) - 2.9594104944408173e-12*(u_vgs - (-0.4999999995046213));
      if (cr < 0.0) inside = 0;
      cr = 0.034113794764288774*(u_vds - (-0.4999999999970406)) - 5.829473690988074e-07*(u_vgs - 0.42334350798949033);
      if (cr < 0.0) inside = 0;
      cr = 0.026864822980150194*(u_vds - (-0.4999994170496715)) - 4.079733367262639e-05*(u_vgs - 0.4574573027537791);
      if (cr < 0.0) inside = 0;
      cr = 0.009015630415252218*(u_vds - (-0.49995861971599886)) - 9.970040023588034e-05*(u_vgs - 0.4843221257339293);
      if (cr < 0.0) inside = 0;
      cr = 0.006567017997501312*(u_vds - (-0.499858919315763)) - 0.00013315382494538675*(u_vgs - 0.4933377561491815);
      if (cr < 0.0) inside = 0;
      cr = 1.0821223415669046e-06*(u_vds - (-0.4997257654908176)) - 6.904458000334124e-07*(u_vgs - 0.49990477414668283);
      if (cr < 0.0) inside = 0;
      cr = 5.717789044790145e-05*(u_vds - (-0.49972507504501756)) - 3.6681906501467854e-05*(u_vgs - 0.4999058562690244);
      if (cr < 0.0) inside = 0;
      cr = 2.2306282936868094e-06*(u_vds - (-0.4996883931385161)) - 1.4390628000904293e-06*(u_vgs - 0.4999630341594723);
      if (cr < 0.0) inside = 0;
      cr = 8.063524681301004e-09*(u_vds - (-0.499686954075716)) - 5.211699960483429e-09*(u_vgs - 0.499965264787766);
      if (cr < 0.0) inside = 0;
      cr = 3.47271487093348e-05*(u_vds - (-0.49968694886401605)) - 2.248287370093527e-05*(u_vgs - 0.49996527285129067);
      if (cr < 0.0) inside = 0;
      cr = (-0.0448694819081929)*(u_vds - (-0.4996644659903151)) - 0.902239361428042*(u_vgs - 0.5);
      if (cr < 0.0) inside = 0;
      cr = (-0.03768579064416239)*(u_vds - 0.40257489543772684) - 0.021477665416650416*(u_vgs - 0.4551305180918071);
      if (cr < 0.0) inside = 0;
      cr = (-0.019615004166576355)*(u_vds - 0.42405256085437726) - 0.01020836285572968*(u_vgs - 0.4174447274476447);
      if (cr < 0.0) inside = 0;
      cr = (-0.041062772128810765)*(u_vds - 0.43426092371010694) - 0.019133815097989837*(u_vgs - 0.39782972328106836);
      if (cr < 0.0) inside = 0;
      cr = (-0.04406744778361449)*(u_vds - 0.4533947388080968) - 0.01703046810393727*(u_vgs - 0.3567669511522576);
      if (cr < 0.0) inside = 0;
      cr = (-0.048050247752786934)*(u_vds - 0.47042520691203404) - 0.014242408137676854*(u_vgs - 0.3126995033686431);
      if (cr < 0.0) inside = 0;
      cr = (-0.0536902534610654)*(u_vds - 0.4846676150497109) - 0.010294262547965505*(u_vgs - 0.26464925561585617);
      if (cr < 0.0) inside = 0;
      cr = (-0.0618544357438216)*(u_vds - 0.4949618775976764) - 0.004579129985961605*(u_vgs - 0.21095900215479077);
      if (cr < 0.0) inside = 0;
      cr = (-0.0677474626858589)*(u_vds - 0.499541007583638) - 0.00045386318044982055*(u_vgs - 0.14910456641096917);
      if (cr < 0.0) inside = 0;
      cr = (-0.06838848819212097)*(u_vds - 0.49999487076408783) - 5.129232941936124e-06*(u_vgs - 0.08135710372511026);
      if (cr < 0.0) inside = 0;
      cr = (-0.5129686155329887)*(u_vds - 0.49999999999702976) - 2.9702351689309126e-12*(u_vgs - 0.012968615532989293);
      if (cr < 0.0) inside = 0;
      cr = (-6.106226635438361e-16)*(u_vds - 0.5) - (-3.3306690738754696e-16)*(u_vgs - (-0.4999999999999994));
      if (cr < 0.0) inside = 0;
      if (inside) begin
        b_vgs = u_vgs;
        b_vds = u_vds;
      end else begin
        t = ((u_vgs - (-0.5))*1.3542333920923966e-11 + (u_vds - 0.49999999999999967)*(-0.19999999999845564))/0.03999999999938225;
        if (t < 0.0) t = 0.0; else if (t > 1.0) t = 1.0;
        cx = (-0.5) + t*1.3542333920923966e-11;
        cy = 0.49999999999999967 + t*(-0.19999999999845564);
        e = (u_vgs - cx)*(u_vgs - cx) + (u_vds - cy)*(u_vds - cy);
        best = e; b_vgs = cx; b_vds = cy;
        t = ((u_vgs - (-0.49999999998645767))*3.3856029091339224e-11 + (u_vds - 0.30000000000154403)*(-0.49999999999613887))/0.24999999999613887;
        if (t < 0.0) t = 0.0; else if (t > 1.0) t = 1.0;
        cx = (-0.49999999998645767) + t*3.3856029091339224e-11;
        cy = 0.30000000000154403 + t*(-0.49999999999613887);
        e = (u_vgs - cx)*(u_vgs - cx) + (u_vds - cy)*(u_vds - cy);
        if (e < best) begin best = e; b_vgs = cx; b_vds = cy; end
        t = ((u_vgs - (-0.49999999995260164))*1.6928125567972074e-11 + (u_vds - (-0.19999999999459486))*(-0.2499999999980694))/0.0624999999990347;
        if (t < 0.0) t = 0.0; else if (t > 1.0) t = 1.0;
        cx = (-0.49999999995260164) + t*1.6928125567972074e-11;
        cy = (-0.19999999999459486) + t*(-0.2499999999980694);
        e = (u_vgs - cx)*(u_vgs - cx) + (u_vds - cy)*(u_vds - cy);
        if (e < best) begin best = e; b_vgs = cx; b_vds = cy; end
        t = ((u_vgs - (-0.4999999999356735))*1.6928680679484387e-12 + (u_vds - (-0.44999999999266427))*(-0.0249999999998069))/0.000624999999990345;
        if (t < 0.0) t = 0.0; else if (t > 1.0) t = 1.0;
        cx = (-0.4999999999356735) + t*1.6928680679484387e-12;
        cy = (-0.44999999999266427) + t*(-0.0249999999998069);
        e = (u_vgs - cx)*(u_vgs - cx) + (u_vds - cy)*(u_vds - cy);
        if (e < best) begin best = e; b_vgs = cx; b_vds = cy; end
        t = ((u_vgs - (-0.49999999993398064))*4.2935932587084835e-10 + (u_vds - (-0.47499999999247117))*(-0.025000000007528833))/0.0006250000003764418;
        if (t < 0.0) t = 0.0; else if (t > 1.0) t = 1.0;
        cx = (-0.49999999993398064) + t*4.2935932587084835e-10;
        cy = (-0.47499999999247117) + t*(-0.025000000007528833);
        e = (u_vgs - cx)*(u_vgs - cx) + (u_vds - cy)*(u_vds - cy);
        if (e < best) begin best = e; b_vgs = cx; b_vds = cy; end
        t = ((u_vgs - (-0.4999999995046213))*0.9233435074941116 + (u_vds - (-0.5))*2.9594104944408173e-12)/0.8525632328315286;
        if (t < 0.0) t = 0.0; else if (t > 1.0) t = 1.0;
        cx = (-0.4999999995046213) + t*0.9233435074941116;
        cy = (-0.5) + t*2.9594104944408173e-12;
        e = (u_vgs - cx)*(u_vgs - cx) + (u_vds - cy)*(u_vds - cy);
        if (e < best) begin best = e; b_vgs = cx; b_vds = cy; end
        t = ((u_vgs - 0.42334350798949033)*0.034113794764288774 + (u_vds - (-0.4999999999970406))*5.829473690988074e-07)/0.0011637509935598436;
        if (t < 0.0) t = 0.0; else if (t > 1.0) t = 1.0;
        cx = 0.42334350798949033 + t*0.034113794764288774;
        cy = (-0.4999999999970406) + t*5.829473690988074e-07;
        e = (u_vgs - cx)*(u_vgs - cx) + (u_vds - cy)*(u_vds - cy);
        if (e < best) begin best = e; b_vgs = cx; b_vds = cy; end
        t = ((u_vgs - 0.4574573027537791)*0.026864822980150194 + (u_vds - (-0.4999994170496715))*4.079733367262639e-05)/0.0007217203781772407;
        if (t < 0.0) t = 0.0; else if (t > 1.0) t = 1.0;
        cx = 0.4574573027537791 + t*0.026864822980150194;
        cy = (-0.4999994170496715) + t*4.079733367262639e-05;
        e = (u_vgs - cx)*(u_vgs - cx) + (u_vds - cy)*(u_vds - cy);
        if (e < best) begin best = e; b_vgs = cx; b_vds = cy; end
        t = ((u_vgs - 0.4843221257339293)*0.009015630415252218 + (u_vds - (-0.49995861971599886))*9.970040023588034e-05)/8.129153195422808e-05;
        if (t < 0.0) t = 0.0; else if (t > 1.0) t = 1.0;
        cx = 0.4843221257339293 + t*0.009015630415252218;
        cy = (-0.49995861971599886) + t*9.970040023588034e-05;
        e = (u_vgs - cx)*(u_vgs - cx) + (u_vds - cy)*(u_vds - cy);
        if (e < best) begin best = e; b_vgs = cx; b_vds = cy; end
        t = ((u_vgs - 0.4933377561491815)*0.006567017997501312 + (u_vds - (-0.499858919315763))*0.00013315382494538675)/4.314345532060373e-05;
        if (t < 0.0) t = 0.0; else if (t > 1.0) t = 1.0;
        cx = 0.4933377561491815 + t*0.006567017997501312;
        cy = (-0.499858919315763) + t*0.00013315382494538675;
        e = (u_vgs - cx)*(u_vgs - cx) + (u_vds - cy)*(u_vds - cy);
        if (e < best) begin best = e; b_vgs = cx; b_vds = cy; end
        t = ((u_vgs - 0.49990477414668283)*1.0821223415669046e-06 + (u_vds - (-0.4997257654908176))*6.904458000334124e-07)/1.6477041649020193e-12;
        if (t < 0.0) t = 0.0; else if (t > 1.0) t = 1.0;
        cx = 0.49990477414668283 + t*1.0821223415669046e-06;
        cy = (-0.4997257654908176) + t*6.904458000334124e-07;
        e = (u_vgs - cx)*(u_vgs - cx) + (u_vds - cy)*(u_vds - cy);
        if (e < best) begin best = e; b_vgs = cx; b_vds = cy; end
        t = ((u_vgs - 0.4999058562690244)*5.717789044790145e-05 + (u_vds - (-0.49972507504501756))*3.6681906501467854e-05)/4.614873420654649e-09;
        if (t < 0.0) t = 0.0; else if (t > 1.0) t = 1.0;
        cx = 0.4999058562690244 + t*5.717789044790145e-05;
        cy = (-0.49972507504501756) + t*3.6681906501467854e-05;
        e = (u_vgs - cx)*(u_vgs - cx) + (u_vds - cy)*(u_vds - cy);
        if (e < best) begin best = e; b_vgs = cx; b_vds = cy; end
        t = ((u_vgs - 0.4999630341594723)*2.2306282936868094e-06 + (u_vds - (-0.4996883931385161))*1.4390628000904293e-06)/7.046604327200234e-12;
        if (t < 0.0) t = 0.0; else if (t > 1.0) t = 1.0;
        cx = 0.4999630341594723 + t*2.2306282936868094e-06;
        cy = (-0.4996883931385161) + t*1.4390628000904293e-06;
        e = (u_vgs - cx)*(u_vgs - cx) + (u_vds - cy)*(u_vds - cy);
        if (e < best) begin best = e; b_vgs = cx; b_vds = cy; end
        t = ((u_vgs - 0.499965264787766)*8.063524681301004e-09 + (u_vds - (-0.499686954075716))*5.211699960483429e-09)/9.218224676405343e-17;
        if (t < 0.0) t = 0.0; else if (t > 1.0) t = 1.0;
        cx = 0.499965264787766 + t*8.063524681301004e-09;
        cy = (-0.499686954075716) + t*5.211699960483429e-09;
        e = (u_vgs - cx)*(u_vgs - cx) + (u_vds - cy)*(u_vds - cy);
        if (e < best) begin best = e; b_vgs = cx; b_vds = cy; end
        t = ((u_vgs - 0.49996527285129067)*3.47271487093348e-05 + (u_vds - (-0.49968694886401605))*2.248287370093527e-05)/1.7114544673324604e-09;
        if (t < 0.0) t = 0.0; else if (t > 1.0) t = 1.0;
        cx = 0.49996527285129067 + t*3.47271487093348e-05;
        cy = (-0.49968694886401605) + t*2.248287370093527e-05;
        e = (u_vgs - cx)*(u_vgs - cx) + (u_vds - cy)*(u_vds - cy);
        if (e < best) begin best = e; b_vgs = cx; b_vds = cy; end
        t = ((u_vgs - 0.5)*(-0.0448694819081929) + (u_vds - (-0.4996644659903151))*0.902239361428042)/0.8160491357167905;
        if (t < 0.0) t = 0.0; else if (t > 1.0) t = 1.0;
        cx = 0.5 + t*(-0.0448694819081929);
        cy = (-0.4996644659903151) + t*0.902239361428042;
        e = (u_vgs - cx)*(u_vgs - cx) + (u_vds - cy)*(u_vds - cy);
        if (e < best) begin best = e; b_vgs = cx; b_vds = cy; end
        t = ((u_vgs - 0.4551305180918071)*(-0.03768579064416239) + (u_vds - 0.40257489543772684)*0.021477665416650416)/0.0018815089282252185;
        if (t < 0.0) t = 0.0; else if (t > 1.0) t = 1.0;
        cx = 0.4551305180918071 + t*(-0.03768579064416239);
        cy = 0.40257489543772684 + t*0.021477665416650416;
        e = (u_vgs - cx)*(u_vgs - cx) + (u_vds - cy)*(u_vds - cy);
        if (e < best) begin best = e; b_vgs = cx; b_vds = cy; end
        t = ((u_vgs - 0.4174447274476447)*(-0.019615004166576355) + (u_vds - 0.42405256085437726)*0.01020836285572968)/0.0004889590606490492;
        if (t < 0.0) t = 0.0; else if (t > 1.0) t = 1.0;
        cx = 0.4174447274476447 + t*(-0.019615004166576355);
        cy = 0.42405256085437726 + t*0.01020836285572968;
        e = (u_vgs - cx)*(u_vgs - cx) + (u_vds - cy)*(u_vds - cy);
        if (e < best) begin best = e; b_vgs = cx; b_vds = cy; end
        t = ((u_vgs - 0.39782972328106836)*(-0.041062772128810765) + (u_vds - 0.43426092371010694)*0.019133815097989837)/0.0020522541351067018;
        if (t < 0.0) t = 0.0; else if (t > 1.0) t = 1.0;
        cx = 0.39782972328106836 + t*(-0.041062772128810765);
        cy = 0.43426092371010694 + t*0.019133815097989837;
        e = (u_vgs - cx)*(u_vgs - cx) + (u_vds - cy)*(u_vds - cy);
        if (e < best) begin best = e; b_vgs = cx; b_vds = cy; end
        t = ((u_vgs - 0.3567669511522576)*(-0.04406744778361449) + (u_vds - 0.4533947388080968)*0.01703046810393727)/0.002231976798000814;
        if (t < 0.0) t = 0.0; else if (t > 1.0) t = 1.0;
        cx = 0.3567669511522576 + t*(-0.04406744778361449);
        cy = 0.4533947388080968 + t*0.01703046810393727;
        e = (u_vgs - cx)*(u_vgs - cx) + (u_vds - cy)*(u_vds - cy);
        if (e < best) begin best = e; b_vgs = cx; b_vds = cy; end
        t = ((u_vgs - 0.3126995033686431)*(-0.048050247752786934) + (u_vds - 0.47042520691203404)*0.014242408137676854)/0.0025116724986643697;
        if (t < 0.0) t = 0.0; else if (t > 1.0) t = 1.0;
        cx = 0.3126995033686431 + t*(-0.048050247752786934);
        cy = 0.47042520691203404 + t*0.014242408137676854;
        e = (u_vgs - cx)*(u_vgs - cx) + (u_vds - cy)*(u_vds - cy);
        if (e < best) begin best = e; b_vgs = cx; b_vds = cy; end
        t = ((u_vgs - 0.26464925561585617)*(-0.0536902534610654) + (u_vds - 0.4846676150497109)*0.010294262547965505)/0.0029886151581198905;
        if (t < 0.0) t = 0.0; else if (t > 1.0) t = 1.0;
        cx = 0.26464925561585617 + t*(-0.0536902534610654);
        cy = 0.4846676150497109 + t*0.010294262547965505;
        e = (u_vgs - cx)*(u_vgs - cx) + (u_vds - cy)*(u_vds - cy);
        if (e < best) begin best = e; b_vgs = cx; b_vds = cy; end
        t = ((u_vgs - 0.21095900215479077)*(-0.0618544357438216) + (u_vds - 0.4949618775976764)*0.004579129985961605)/0.003846939652614888;
        if (t < 0.0) t = 0.0; else if (t > 1.0) t = 1.0;
        cx = 0.21095900215479077 + t*(-0.0618544357438216);
        cy = 0.4949618775976764 + t*0.004579129985961605;
        e = (u_vgs - cx)*(u_vgs - cx) + (u_vds - cy)*(u_vds - cy);
        if (e < best) begin best = e; b_vgs = cx; b_vds = cy; end
        t = ((u_vgs - 0.14910456641096917)*(-0.0677474626858589) + (u_vds - 0.499541007583638)*0.00045386318044982055)/0.0045899246921584135;
        if (t < 0.0) t = 0.0; else if (t > 1.0) t = 1.0;
        cx = 0.14910456641096917 + t*(-0.0677474626858589);
        cy = 0.499541007583638 + t*0.00045386318044982055;
        e = (u_vgs - cx)*(u_vgs - cx) + (u_vds - cy)*(u_vds - cy);
        if (e < best) begin best = e; b_vgs = cx; b_vds = cy; end
        t = ((u_vgs - 0.08135710372511026)*(-0.06838848819212097) + (u_vds - 0.49999487076408783)*5.129232941936124e-06)/0.004676985343512899;
        if (t < 0.0) t = 0.0; else if (t > 1.0) t = 1.0;
        cx = 0.08135710372511026 + t*(-0.06838848819212097);
        cy = 0.49999487076408783 + t*5.129232941936124e-06;
        e = (u_vgs - cx)*(u_vgs - cx) + (u_vds - cy)*(u_vds - cy);
        if (e < best) begin best = e; b_vgs = cx; b_vds = cy; end
        t = ((u_vgs - 0.012968615532989293)*(-0.5129686155329887) + (u_vds - 0.49999999999702976)*2.9702351689309126e-12)/0.26313680052183114;
        if (t < 0.0) t = 0.0; else if (t > 1.0) t = 1.0;
        cx = 0.012968615532989293 + t*(-0.5129686155329887);
        cy = 0.49999999999702976 + t*2.9702351689309126e-12;
        e = (u_vgs - cx)*(u_vgs - cx) + (u_vds - cy)*(u_vds - cy);
        if (e < best) begin best = e; b_vgs = cx; b_vds = cy; end
        t = ((u_vgs - (-0.4999999999999994))*(-6.106226635438361e-16) + (u_vds - 0.5)*(-3.3306690738754696e-16))/4.8379360203007365e-31;
        if (t < 0.0) t = 0.0; else if (t > 1.0) t = 1.0;
        cx = (-0.4999999999999994) + t*(-6.106226635438361e-16);
        cy = 0.5 + t*(-3.3306690738754696e-16);
        e = (u_vgs - cx)*(u_vgs - cx) + (u_vds - cy)*(u_vds - cy);
        if (e < best) begin best = e; b_vgs = cx; b_vds = cy; end
      end
      // the nearest domain point: the point itself inside, else back from normalised coordinates
      if (inside && inbox) begin
        p_vgs = vgs;
        p_vds = vds;
        p_T = T;
        p_phi2 = phi2;
      end else begin
        p_vgs = (-2.075844497250043) + 5.848311005851915*b_vgs;
        p_vds = 9.999999999453182 + 19.99999999902244*b_vds;
        p_T = 75.0 + 100.0*b_T;
        p_phi2 = 9.9999999999008 + 19.999999999830397*b_phi2;
      end
      fb = f_Id(p_vgs, p_vds, p_T, p_phi2, g_vgs, g_vds, g_T, g_phi2);
      x_Id = fb + g_vgs*(vgs - p_vgs) + g_vds*(vds - p_vds) + g_T*(T - p_T) + g_phi2*(phi2 - p_phi2);
      dist2 = (u_vgs - b_vgs)*(u_vgs - b_vgs) + (u_vds - b_vds)*(u_vds - b_vds) + (u_T - b_T)*(u_T - b_T) + (u_phi2 - b_phi2)*(u_phi2 - b_phi2);
      s = (vds - p_vds);
      // the added conductance on the constituent's own branch: ten times the edge's own, floored, capped by G_x
      ga = 10.0*(g_vds*1.0);
      gl = min(sqrt(ga*ga + (1e-07*Gx_Id)*(1e-07*Gx_Id)), Gx_Id);
      if (dist2 > 0.0) x_Id = x_Id + (gl/0.05)*s*sqrt(dist2);
    end
  endfunction

  // Core.Constituents.Ig.IgGs (ANN, 2 hidden layers of 8 x 8, Tanh), the current 6.132197822999999e-09*sinh(u) (Transform: Asinh)
  analog function real f_IgGs;
    input vgs, vds, T;
    output d_vgs, d_vds, d_T;
    real vgs, vds, T;
    real d_vgs, d_vds, d_T;
    real z, x1, x2, x3, h1_1, h1_1_vgs, h1_1_vds, h1_1_T, h1_2, h1_2_vgs, h1_2_vds, h1_2_T;
    real h1_3, h1_3_vgs, h1_3_vds, h1_3_T, h1_4, h1_4_vgs, h1_4_vds, h1_4_T, h1_5, h1_5_vgs, h1_5_vds, h1_5_T;
    real h1_6, h1_6_vgs, h1_6_vds, h1_6_T, h1_7, h1_7_vgs, h1_7_vds, h1_7_T, h1_8, h1_8_vgs, h1_8_vds, h1_8_T;
    real h2_1, h2_1_vgs, h2_1_vds, h2_1_T, h2_2, h2_2_vgs, h2_2_vds, h2_2_T, h2_3, h2_3_vgs, h2_3_vds, h2_3_T;
    real h2_4, h2_4_vgs, h2_4_vds, h2_4_T, h2_5, h2_5_vgs, h2_5_vds, h2_5_T, h2_6, h2_6_vgs, h2_6_vds, h2_6_T;
    real h2_7, h2_7_vgs, h2_7_vds, h2_7_T, h2_8, h2_8_vgs, h2_8_vds, h2_8_T, u, u_vgs, u_vds, u_T;
    real w, sh, ch;
    begin
      x1 = (vgs - (-2.075844497250043))*0.3419790770358771;
      x2 = (vds - 9.999999999453182)*0.1000000000048878;
      x3 = (T - 75.0)*0.02;
      // hidden layer 1
      z = -5.535211995366623 + 2.7479158283359326*x1 - 3.0706294462859263*x2 + 0.007538176955019518*x3;
      h1_1 = tanh(z);
      h1_1_vgs = (1.0 - h1_1*h1_1)*(0.9397297187465999);
      h1_1_vds = (1.0 - h1_1*h1_1)*(-0.3070629446436013);
      h1_1_T = (1.0 - h1_1*h1_1)*(0.00015076353910039035);
      z = 5.496430298548648 - 6.706943307519755*x1 - 0.03934862185956259*x2 + 0.0008336183675109822*x3;
      h1_2 = tanh(z);
      h1_2_vgs = (1.0 - h1_2*h1_2)*(-2.2936342820375586);
      h1_2_vds = (1.0 - h1_2*h1_2)*(-0.003934862186148587);
      h1_2_T = (1.0 - h1_2*h1_2)*(1.6672367350219646e-05);
      z = -2.651101979657477 + 3.339015261504249*x1 + 0.031905348090340735*x2 + 0.0028918474748569787*x3;
      h1_3 = tanh(z);
      h1_3_vgs = (1.0 - h1_3*h1_3)*(1.141873357337931);
      h1_3_vds = (1.0 - h1_3*h1_3)*(0.0031905348091900206);
      h1_3_T = (1.0 - h1_3*h1_3)*(5.783694949713958e-05);
      z = 3.8742182571231747 - 5.098408032168937*x1 + 0.06426331816675125*x2 + 0.0023334187333611854*x3;
      h1_4 = tanh(z);
      h1_4_vgs = (1.0 - h1_4*h1_4)*(-1.7435488731934354);
      h1_4_vds = (1.0 - h1_4*h1_4)*(0.006426331816989232);
      h1_4_T = (1.0 - h1_4*h1_4)*(4.666837466722371e-05);
      z = -6.847026835189308 - 1.3180898584781457*x1 - 7.7545049007673565*x2 - 0.0493573103805105*x3;
      h1_5 = tanh(z);
      h1_5_vgs = (1.0 - h1_5*h1_5)*(-0.45075915325270616);
      h1_5_vds = (1.0 - h1_5*h1_5)*(-0.7754504901146382);
      h1_5_T = (1.0 - h1_5*h1_5)*(-0.00098714620761021);
      z = 3.070018180402428 - 0.8509738945186168*x1 + 0.49973858112709135*x2 - 0.06291784808605833*x3;
      h1_6 = tanh(z);
      h1_6_vgs = (1.0 - h1_6*h1_6)*(-0.2910152670291024);
      h1_6_vds = (1.0 - h1_6*h1_6)*(0.04997385811515176);
      h1_6_T = (1.0 - h1_6*h1_6)*(-0.0012583569617211664);
      z = 6.780534821094096 + 6.960841949475417*x1 + 12.281270214947046*x2 + 0.03787764049372364*x3;
      h1_7 = tanh(z);
      h1_7_vgs = (1.0 - h1_7*h1_7)*(2.3804623052742184);
      h1_7_vds = (1.0 - h1_7*h1_7)*(1.228127021554733);
      h1_7_T = (1.0 - h1_7*h1_7)*(0.0007575528098744729);
      z = 0.7653524149029431 - 3.52029582990352*x1 - 2.1019753216347064*x2 + 0.08514809096942752*x3;
      h1_8 = tanh(z);
      h1_8_vgs = (1.0 - h1_8*h1_8)*(-1.2038675188036527);
      h1_8_vds = (1.0 - h1_8*h1_8)*(-0.21019753217374468);
      h1_8_T = (1.0 - h1_8*h1_8)*(0.0017029618193885505);
      // hidden layer 2
      z = -0.7654986316018392 - 0.5975329475738348*h1_1 + 1.3681739358182434*h1_2 - 1.5410326225777213*h1_3 + 1.9107443685024394*h1_4 + 0.41579599946987233*h1_5 + 0.5192383344499234*h1_6 + 0.03469742893333906*h1_7 + 0.032047525776714325*h1_8;
      h2_1 = tanh(z);
      h2_1_vgs = (1.0 - h2_1*h2_1)*(- 0.5975329475738348*h1_1_vgs + 1.3681739358182434*h1_2_vgs - 1.5410326225777213*h1_3_vgs + 1.9107443685024394*h1_4_vgs + 0.41579599946987233*h1_5_vgs + 0.5192383344499234*h1_6_vgs + 0.03469742893333906*h1_7_vgs + 0.032047525776714325*h1_8_vgs);
      h2_1_vds = (1.0 - h2_1*h2_1)*(- 0.5975329475738348*h1_1_vds + 1.3681739358182434*h1_2_vds - 1.5410326225777213*h1_3_vds + 1.9107443685024394*h1_4_vds + 0.41579599946987233*h1_5_vds + 0.5192383344499234*h1_6_vds + 0.03469742893333906*h1_7_vds + 0.032047525776714325*h1_8_vds);
      h2_1_T = (1.0 - h2_1*h2_1)*(- 0.5975329475738348*h1_1_T + 1.3681739358182434*h1_2_T - 1.5410326225777213*h1_3_T + 1.9107443685024394*h1_4_T + 0.41579599946987233*h1_5_T + 0.5192383344499234*h1_6_T + 0.03469742893333906*h1_7_T + 0.032047525776714325*h1_8_T);
      z = -0.5998339666594 + 3.742806514849544*h1_1 - 6.173841742002743*h1_2 + 1.6577457373140885*h1_3 - 3.2449028481720594*h1_4 + 1.680266866465975*h1_5 - 3.9619838521212767*h1_6 + 5.902614260293402*h1_7 - 2.00071827602475*h1_8;
      h2_2 = tanh(z);
      h2_2_vgs = (1.0 - h2_2*h2_2)*(3.742806514849544*h1_1_vgs - 6.173841742002743*h1_2_vgs + 1.6577457373140885*h1_3_vgs - 3.2449028481720594*h1_4_vgs + 1.680266866465975*h1_5_vgs - 3.9619838521212767*h1_6_vgs + 5.902614260293402*h1_7_vgs - 2.00071827602475*h1_8_vgs);
      h2_2_vds = (1.0 - h2_2*h2_2)*(3.742806514849544*h1_1_vds - 6.173841742002743*h1_2_vds + 1.6577457373140885*h1_3_vds - 3.2449028481720594*h1_4_vds + 1.680266866465975*h1_5_vds - 3.9619838521212767*h1_6_vds + 5.902614260293402*h1_7_vds - 2.00071827602475*h1_8_vds);
      h2_2_T = (1.0 - h2_2*h2_2)*(3.742806514849544*h1_1_T - 6.173841742002743*h1_2_T + 1.6577457373140885*h1_3_T - 3.2449028481720594*h1_4_T + 1.680266866465975*h1_5_T - 3.9619838521212767*h1_6_T + 5.902614260293402*h1_7_T - 2.00071827602475*h1_8_T);
      z = -1.6955157624953507 + 0.004654212652469439*h1_1 - 0.29647986977943125*h1_2 + 0.785666001208236*h1_3 - 0.7871556833699433*h1_4 + 0.03722598208246819*h1_5 + 0.1985679603556207*h1_6 - 0.05534086061931226*h1_7 + 0.03759994065904063*h1_8;
      h2_3 = tanh(z);
      h2_3_vgs = (1.0 - h2_3*h2_3)*(0.004654212652469439*h1_1_vgs - 0.29647986977943125*h1_2_vgs + 0.785666001208236*h1_3_vgs - 0.7871556833699433*h1_4_vgs + 0.03722598208246819*h1_5_vgs + 0.1985679603556207*h1_6_vgs - 0.05534086061931226*h1_7_vgs + 0.03759994065904063*h1_8_vgs);
      h2_3_vds = (1.0 - h2_3*h2_3)*(0.004654212652469439*h1_1_vds - 0.29647986977943125*h1_2_vds + 0.785666001208236*h1_3_vds - 0.7871556833699433*h1_4_vds + 0.03722598208246819*h1_5_vds + 0.1985679603556207*h1_6_vds - 0.05534086061931226*h1_7_vds + 0.03759994065904063*h1_8_vds);
      h2_3_T = (1.0 - h2_3*h2_3)*(0.004654212652469439*h1_1_T - 0.29647986977943125*h1_2_T + 0.785666001208236*h1_3_T - 0.7871556833699433*h1_4_T + 0.03722598208246819*h1_5_T + 0.1985679603556207*h1_6_T - 0.05534086061931226*h1_7_T + 0.03759994065904063*h1_8_T);
      z = 0.9147275816601421 - 5.867073874397325*h1_1 + 6.7023007323418184*h1_2 - 3.1381420730358895*h1_3 + 4.244553153985932*h1_4 + 0.725767318067895*h1_5 + 0.8655479250321914*h1_6 - 1.4485834777099063*h1_7 + 2.7554388479179837*h1_8;
      h2_4 = tanh(z);
      h2_4_vgs = (1.0 - h2_4*h2_4)*(- 5.867073874397325*h1_1_vgs + 6.7023007323418184*h1_2_vgs - 3.1381420730358895*h1_3_vgs + 4.244553153985932*h1_4_vgs + 0.725767318067895*h1_5_vgs + 0.8655479250321914*h1_6_vgs - 1.4485834777099063*h1_7_vgs + 2.7554388479179837*h1_8_vgs);
      h2_4_vds = (1.0 - h2_4*h2_4)*(- 5.867073874397325*h1_1_vds + 6.7023007323418184*h1_2_vds - 3.1381420730358895*h1_3_vds + 4.244553153985932*h1_4_vds + 0.725767318067895*h1_5_vds + 0.8655479250321914*h1_6_vds - 1.4485834777099063*h1_7_vds + 2.7554388479179837*h1_8_vds);
      h2_4_T = (1.0 - h2_4*h2_4)*(- 5.867073874397325*h1_1_T + 6.7023007323418184*h1_2_T - 3.1381420730358895*h1_3_T + 4.244553153985932*h1_4_T + 0.725767318067895*h1_5_T + 0.8655479250321914*h1_6_T - 1.4485834777099063*h1_7_T + 2.7554388479179837*h1_8_T);
      z = -0.57643952149711 - 0.26217754119169256*h1_1 + 0.5870482925967888*h1_2 - 0.8687586293802719*h1_3 + 0.8663313213636825*h1_4 - 0.05022728859790034*h1_5 - 0.13993470254598256*h1_6 + 0.08201119339892987*h1_7 - 0.006103042330642228*h1_8;
      h2_5 = tanh(z);
      h2_5_vgs = (1.0 - h2_5*h2_5)*(- 0.26217754119169256*h1_1_vgs + 0.5870482925967888*h1_2_vgs - 0.8687586293802719*h1_3_vgs + 0.8663313213636825*h1_4_vgs - 0.05022728859790034*h1_5_vgs - 0.13993470254598256*h1_6_vgs + 0.08201119339892987*h1_7_vgs - 0.006103042330642228*h1_8_vgs);
      h2_5_vds = (1.0 - h2_5*h2_5)*(- 0.26217754119169256*h1_1_vds + 0.5870482925967888*h1_2_vds - 0.8687586293802719*h1_3_vds + 0.8663313213636825*h1_4_vds - 0.05022728859790034*h1_5_vds - 0.13993470254598256*h1_6_vds + 0.08201119339892987*h1_7_vds - 0.006103042330642228*h1_8_vds);
      h2_5_T = (1.0 - h2_5*h2_5)*(- 0.26217754119169256*h1_1_T + 0.5870482925967888*h1_2_T - 0.8687586293802719*h1_3_T + 0.8663313213636825*h1_4_T - 0.05022728859790034*h1_5_T - 0.13993470254598256*h1_6_T + 0.08201119339892987*h1_7_T - 0.006103042330642228*h1_8_T);
      z = 0.6137442659917894 - 2.1367857873231624*h1_1 + 0.7537247082988835*h1_2 - 1.0338301582280618*h1_3 + 1.8680974860344073*h1_4 - 2.348267220563797*h1_5 + 0.5207662962033671*h1_6 + 1.7942579422391753*h1_7 - 0.468182668418492*h1_8;
      h2_6 = tanh(z);
      h2_6_vgs = (1.0 - h2_6*h2_6)*(- 2.1367857873231624*h1_1_vgs + 0.7537247082988835*h1_2_vgs - 1.0338301582280618*h1_3_vgs + 1.8680974860344073*h1_4_vgs - 2.348267220563797*h1_5_vgs + 0.5207662962033671*h1_6_vgs + 1.7942579422391753*h1_7_vgs - 0.468182668418492*h1_8_vgs);
      h2_6_vds = (1.0 - h2_6*h2_6)*(- 2.1367857873231624*h1_1_vds + 0.7537247082988835*h1_2_vds - 1.0338301582280618*h1_3_vds + 1.8680974860344073*h1_4_vds - 2.348267220563797*h1_5_vds + 0.5207662962033671*h1_6_vds + 1.7942579422391753*h1_7_vds - 0.468182668418492*h1_8_vds);
      h2_6_T = (1.0 - h2_6*h2_6)*(- 2.1367857873231624*h1_1_T + 0.7537247082988835*h1_2_T - 1.0338301582280618*h1_3_T + 1.8680974860344073*h1_4_T - 2.348267220563797*h1_5_T + 0.5207662962033671*h1_6_T + 1.7942579422391753*h1_7_T - 0.468182668418492*h1_8_T);
      z = -0.37794373755128213 + 1.1673138543568613*h1_1 - 0.23588181120866114*h1_2 + 1.571947479565582*h1_3 - 0.8904867027011502*h1_4 + 2.472856666219593*h1_5 - 0.5703013565525424*h1_6 - 0.538850477861779*h1_7 - 0.047461560567413595*h1_8;
      h2_7 = tanh(z);
      h2_7_vgs = (1.0 - h2_7*h2_7)*(1.1673138543568613*h1_1_vgs - 0.23588181120866114*h1_2_vgs + 1.571947479565582*h1_3_vgs - 0.8904867027011502*h1_4_vgs + 2.472856666219593*h1_5_vgs - 0.5703013565525424*h1_6_vgs - 0.538850477861779*h1_7_vgs - 0.047461560567413595*h1_8_vgs);
      h2_7_vds = (1.0 - h2_7*h2_7)*(1.1673138543568613*h1_1_vds - 0.23588181120866114*h1_2_vds + 1.571947479565582*h1_3_vds - 0.8904867027011502*h1_4_vds + 2.472856666219593*h1_5_vds - 0.5703013565525424*h1_6_vds - 0.538850477861779*h1_7_vds - 0.047461560567413595*h1_8_vds);
      h2_7_T = (1.0 - h2_7*h2_7)*(1.1673138543568613*h1_1_T - 0.23588181120866114*h1_2_T + 1.571947479565582*h1_3_T - 0.8904867027011502*h1_4_T + 2.472856666219593*h1_5_T - 0.5703013565525424*h1_6_T - 0.538850477861779*h1_7_T - 0.047461560567413595*h1_8_T);
      z = -1.4249590684296365 + 0.03183093657080177*h1_1 - 2.6573080846678936*h1_2 - 0.5259254376277316*h1_3 - 1.6418142324795537*h1_4 - 1.3460965512591536*h1_5 - 1.4111180154768923*h1_6 - 0.8850423447712157*h1_7 - 0.8901269438180263*h1_8;
      h2_8 = tanh(z);
      h2_8_vgs = (1.0 - h2_8*h2_8)*(0.03183093657080177*h1_1_vgs - 2.6573080846678936*h1_2_vgs - 0.5259254376277316*h1_3_vgs - 1.6418142324795537*h1_4_vgs - 1.3460965512591536*h1_5_vgs - 1.4111180154768923*h1_6_vgs - 0.8850423447712157*h1_7_vgs - 0.8901269438180263*h1_8_vgs);
      h2_8_vds = (1.0 - h2_8*h2_8)*(0.03183093657080177*h1_1_vds - 2.6573080846678936*h1_2_vds - 0.5259254376277316*h1_3_vds - 1.6418142324795537*h1_4_vds - 1.3460965512591536*h1_5_vds - 1.4111180154768923*h1_6_vds - 0.8850423447712157*h1_7_vds - 0.8901269438180263*h1_8_vds);
      h2_8_T = (1.0 - h2_8*h2_8)*(0.03183093657080177*h1_1_T - 2.6573080846678936*h1_2_T - 0.5259254376277316*h1_3_T - 1.6418142324795537*h1_4_T - 1.3460965512591536*h1_5_T - 1.4111180154768923*h1_6_T - 0.8850423447712157*h1_7_T - 0.8901269438180263*h1_8_T);
      // output
      u = 1.8016744289927416 + 0.05666813849976076*h2_1 + 0.4431994442399841*h2_2 + 2.4603465653668564*h2_3 + 0.3324115838410614*h2_4 + 0.09564344727417298*h2_5 - 0.7094118138982394*h2_6 - 0.3889587674679498*h2_7 + 0.058243631483377106*h2_8;
      u_vgs = 0.05666813849976076*h2_1_vgs + 0.4431994442399841*h2_2_vgs + 2.4603465653668564*h2_3_vgs + 0.3324115838410614*h2_4_vgs + 0.09564344727417298*h2_5_vgs - 0.7094118138982394*h2_6_vgs - 0.3889587674679498*h2_7_vgs + 0.058243631483377106*h2_8_vgs;
      u_vds = 0.05666813849976076*h2_1_vds + 0.4431994442399841*h2_2_vds + 2.4603465653668564*h2_3_vds + 0.3324115838410614*h2_4_vds + 0.09564344727417298*h2_5_vds - 0.7094118138982394*h2_6_vds - 0.3889587674679498*h2_7_vds + 0.058243631483377106*h2_8_vds;
      u_T = 0.05666813849976076*h2_1_T + 0.4431994442399841*h2_2_T + 2.4603465653668564*h2_3_T + 0.3324115838410614*h2_4_T + 0.09564344727417298*h2_5_T - 0.7094118138982394*h2_6_T - 0.3889587674679498*h2_7_T + 0.058243631483377106*h2_8_T;
      w = 8.38111193683008 + 8.430130894688187*u;
      sh = 6.132197822999999e-09*sinh(w);
      ch = 6.132197822999999e-09*cosh(w);
      f_IgGs = sh;
      d_vgs = (8.430130894688187*u_vgs)*ch;
      d_vds = (8.430130894688187*u_vds)*ch;
      d_T = (8.430130894688187*u_T)*ch;
    end
  endfunction

  // Core.Constituents.Ig.IgGs continued outside Core.Constituents.Ig.Domain (guided extrapolation)
  analog function real x_IgGs;
    input vgs, vds, T;
    real vgs, vds, T;
    real u_vgs, u_vds, u_T, b_vgs, b_vds, b_T, p_vgs, p_vds, p_T, g_vgs, g_vds, g_T;
    real t, cx, cy, e, best, cr, fb, s, dist2, gl, ga;
    integer inside, inbox;
    begin
      // normalised by the domain's centre and extent
      u_vgs = (vgs - (-2.075844497250043))/5.848311005851915;
      u_vds = (vds - 9.999999999453182)/19.99999999902244;
      u_T = (T - 75.0)/100.0;
      inbox = 1;
      // Domain.Box.T
      if (u_T < (-0.5)) begin b_T = (-0.5); inbox = 0; end
      else if (u_T > 0.5) begin b_T = 0.5; inbox = 0; end
      else b_T = u_T;
      // Domain.Polygon: 27 vertices, counter-clockwise
      inside = 1;
      cr = 1.3542333920923966e-11*(u_vds - 0.49999999999999967) - (-0.19999999999845564)*(u_vgs - (-0.5));
      if (cr < 0.0) inside = 0;
      cr = 3.3856029091339224e-11*(u_vds - 0.30000000000154403) - (-0.49999999999613887)*(u_vgs - (-0.49999999998645767));
      if (cr < 0.0) inside = 0;
      cr = 1.6928125567972074e-11*(u_vds - (-0.19999999999459486)) - (-0.2499999999980694)*(u_vgs - (-0.49999999995260164));
      if (cr < 0.0) inside = 0;
      cr = 1.6928680679484387e-12*(u_vds - (-0.44999999999266427)) - (-0.0249999999998069)*(u_vgs - (-0.4999999999356735));
      if (cr < 0.0) inside = 0;
      cr = 4.2935932587084835e-10*(u_vds - (-0.47499999999247117)) - (-0.025000000007528833)*(u_vgs - (-0.49999999993398064));
      if (cr < 0.0) inside = 0;
      cr = 0.9233435074941116*(u_vds - (-0.5)) - 2.9594104944408173e-12*(u_vgs - (-0.4999999995046213));
      if (cr < 0.0) inside = 0;
      cr = 0.034113794764288774*(u_vds - (-0.4999999999970406)) - 5.829473690988074e-07*(u_vgs - 0.42334350798949033);
      if (cr < 0.0) inside = 0;
      cr = 0.026864822980150194*(u_vds - (-0.4999994170496715)) - 4.079733367262639e-05*(u_vgs - 0.4574573027537791);
      if (cr < 0.0) inside = 0;
      cr = 0.009015630415252218*(u_vds - (-0.49995861971599886)) - 9.970040023588034e-05*(u_vgs - 0.4843221257339293);
      if (cr < 0.0) inside = 0;
      cr = 0.006567017997501312*(u_vds - (-0.499858919315763)) - 0.00013315382494538675*(u_vgs - 0.4933377561491815);
      if (cr < 0.0) inside = 0;
      cr = 1.0821223415669046e-06*(u_vds - (-0.4997257654908176)) - 6.904458000334124e-07*(u_vgs - 0.49990477414668283);
      if (cr < 0.0) inside = 0;
      cr = 5.717789044790145e-05*(u_vds - (-0.49972507504501756)) - 3.6681906501467854e-05*(u_vgs - 0.4999058562690244);
      if (cr < 0.0) inside = 0;
      cr = 2.2306282936868094e-06*(u_vds - (-0.4996883931385161)) - 1.4390628000904293e-06*(u_vgs - 0.4999630341594723);
      if (cr < 0.0) inside = 0;
      cr = 8.063524681301004e-09*(u_vds - (-0.499686954075716)) - 5.211699960483429e-09*(u_vgs - 0.499965264787766);
      if (cr < 0.0) inside = 0;
      cr = 3.47271487093348e-05*(u_vds - (-0.49968694886401605)) - 2.248287370093527e-05*(u_vgs - 0.49996527285129067);
      if (cr < 0.0) inside = 0;
      cr = (-0.0448694819081929)*(u_vds - (-0.4996644659903151)) - 0.902239361428042*(u_vgs - 0.5);
      if (cr < 0.0) inside = 0;
      cr = (-0.03768579064416239)*(u_vds - 0.40257489543772684) - 0.021477665416650416*(u_vgs - 0.4551305180918071);
      if (cr < 0.0) inside = 0;
      cr = (-0.019615004166576355)*(u_vds - 0.42405256085437726) - 0.01020836285572968*(u_vgs - 0.4174447274476447);
      if (cr < 0.0) inside = 0;
      cr = (-0.041062772128810765)*(u_vds - 0.43426092371010694) - 0.019133815097989837*(u_vgs - 0.39782972328106836);
      if (cr < 0.0) inside = 0;
      cr = (-0.04406744778361449)*(u_vds - 0.4533947388080968) - 0.01703046810393727*(u_vgs - 0.3567669511522576);
      if (cr < 0.0) inside = 0;
      cr = (-0.048050247752786934)*(u_vds - 0.47042520691203404) - 0.014242408137676854*(u_vgs - 0.3126995033686431);
      if (cr < 0.0) inside = 0;
      cr = (-0.0536902534610654)*(u_vds - 0.4846676150497109) - 0.010294262547965505*(u_vgs - 0.26464925561585617);
      if (cr < 0.0) inside = 0;
      cr = (-0.0618544357438216)*(u_vds - 0.4949618775976764) - 0.004579129985961605*(u_vgs - 0.21095900215479077);
      if (cr < 0.0) inside = 0;
      cr = (-0.0677474626858589)*(u_vds - 0.499541007583638) - 0.00045386318044982055*(u_vgs - 0.14910456641096917);
      if (cr < 0.0) inside = 0;
      cr = (-0.06838848819212097)*(u_vds - 0.49999487076408783) - 5.129232941936124e-06*(u_vgs - 0.08135710372511026);
      if (cr < 0.0) inside = 0;
      cr = (-0.5129686155329887)*(u_vds - 0.49999999999702976) - 2.9702351689309126e-12*(u_vgs - 0.012968615532989293);
      if (cr < 0.0) inside = 0;
      cr = (-6.106226635438361e-16)*(u_vds - 0.5) - (-3.3306690738754696e-16)*(u_vgs - (-0.4999999999999994));
      if (cr < 0.0) inside = 0;
      if (inside) begin
        b_vgs = u_vgs;
        b_vds = u_vds;
      end else begin
        t = ((u_vgs - (-0.5))*1.3542333920923966e-11 + (u_vds - 0.49999999999999967)*(-0.19999999999845564))/0.03999999999938225;
        if (t < 0.0) t = 0.0; else if (t > 1.0) t = 1.0;
        cx = (-0.5) + t*1.3542333920923966e-11;
        cy = 0.49999999999999967 + t*(-0.19999999999845564);
        e = (u_vgs - cx)*(u_vgs - cx) + (u_vds - cy)*(u_vds - cy);
        best = e; b_vgs = cx; b_vds = cy;
        t = ((u_vgs - (-0.49999999998645767))*3.3856029091339224e-11 + (u_vds - 0.30000000000154403)*(-0.49999999999613887))/0.24999999999613887;
        if (t < 0.0) t = 0.0; else if (t > 1.0) t = 1.0;
        cx = (-0.49999999998645767) + t*3.3856029091339224e-11;
        cy = 0.30000000000154403 + t*(-0.49999999999613887);
        e = (u_vgs - cx)*(u_vgs - cx) + (u_vds - cy)*(u_vds - cy);
        if (e < best) begin best = e; b_vgs = cx; b_vds = cy; end
        t = ((u_vgs - (-0.49999999995260164))*1.6928125567972074e-11 + (u_vds - (-0.19999999999459486))*(-0.2499999999980694))/0.0624999999990347;
        if (t < 0.0) t = 0.0; else if (t > 1.0) t = 1.0;
        cx = (-0.49999999995260164) + t*1.6928125567972074e-11;
        cy = (-0.19999999999459486) + t*(-0.2499999999980694);
        e = (u_vgs - cx)*(u_vgs - cx) + (u_vds - cy)*(u_vds - cy);
        if (e < best) begin best = e; b_vgs = cx; b_vds = cy; end
        t = ((u_vgs - (-0.4999999999356735))*1.6928680679484387e-12 + (u_vds - (-0.44999999999266427))*(-0.0249999999998069))/0.000624999999990345;
        if (t < 0.0) t = 0.0; else if (t > 1.0) t = 1.0;
        cx = (-0.4999999999356735) + t*1.6928680679484387e-12;
        cy = (-0.44999999999266427) + t*(-0.0249999999998069);
        e = (u_vgs - cx)*(u_vgs - cx) + (u_vds - cy)*(u_vds - cy);
        if (e < best) begin best = e; b_vgs = cx; b_vds = cy; end
        t = ((u_vgs - (-0.49999999993398064))*4.2935932587084835e-10 + (u_vds - (-0.47499999999247117))*(-0.025000000007528833))/0.0006250000003764418;
        if (t < 0.0) t = 0.0; else if (t > 1.0) t = 1.0;
        cx = (-0.49999999993398064) + t*4.2935932587084835e-10;
        cy = (-0.47499999999247117) + t*(-0.025000000007528833);
        e = (u_vgs - cx)*(u_vgs - cx) + (u_vds - cy)*(u_vds - cy);
        if (e < best) begin best = e; b_vgs = cx; b_vds = cy; end
        t = ((u_vgs - (-0.4999999995046213))*0.9233435074941116 + (u_vds - (-0.5))*2.9594104944408173e-12)/0.8525632328315286;
        if (t < 0.0) t = 0.0; else if (t > 1.0) t = 1.0;
        cx = (-0.4999999995046213) + t*0.9233435074941116;
        cy = (-0.5) + t*2.9594104944408173e-12;
        e = (u_vgs - cx)*(u_vgs - cx) + (u_vds - cy)*(u_vds - cy);
        if (e < best) begin best = e; b_vgs = cx; b_vds = cy; end
        t = ((u_vgs - 0.42334350798949033)*0.034113794764288774 + (u_vds - (-0.4999999999970406))*5.829473690988074e-07)/0.0011637509935598436;
        if (t < 0.0) t = 0.0; else if (t > 1.0) t = 1.0;
        cx = 0.42334350798949033 + t*0.034113794764288774;
        cy = (-0.4999999999970406) + t*5.829473690988074e-07;
        e = (u_vgs - cx)*(u_vgs - cx) + (u_vds - cy)*(u_vds - cy);
        if (e < best) begin best = e; b_vgs = cx; b_vds = cy; end
        t = ((u_vgs - 0.4574573027537791)*0.026864822980150194 + (u_vds - (-0.4999994170496715))*4.079733367262639e-05)/0.0007217203781772407;
        if (t < 0.0) t = 0.0; else if (t > 1.0) t = 1.0;
        cx = 0.4574573027537791 + t*0.026864822980150194;
        cy = (-0.4999994170496715) + t*4.079733367262639e-05;
        e = (u_vgs - cx)*(u_vgs - cx) + (u_vds - cy)*(u_vds - cy);
        if (e < best) begin best = e; b_vgs = cx; b_vds = cy; end
        t = ((u_vgs - 0.4843221257339293)*0.009015630415252218 + (u_vds - (-0.49995861971599886))*9.970040023588034e-05)/8.129153195422808e-05;
        if (t < 0.0) t = 0.0; else if (t > 1.0) t = 1.0;
        cx = 0.4843221257339293 + t*0.009015630415252218;
        cy = (-0.49995861971599886) + t*9.970040023588034e-05;
        e = (u_vgs - cx)*(u_vgs - cx) + (u_vds - cy)*(u_vds - cy);
        if (e < best) begin best = e; b_vgs = cx; b_vds = cy; end
        t = ((u_vgs - 0.4933377561491815)*0.006567017997501312 + (u_vds - (-0.499858919315763))*0.00013315382494538675)/4.314345532060373e-05;
        if (t < 0.0) t = 0.0; else if (t > 1.0) t = 1.0;
        cx = 0.4933377561491815 + t*0.006567017997501312;
        cy = (-0.499858919315763) + t*0.00013315382494538675;
        e = (u_vgs - cx)*(u_vgs - cx) + (u_vds - cy)*(u_vds - cy);
        if (e < best) begin best = e; b_vgs = cx; b_vds = cy; end
        t = ((u_vgs - 0.49990477414668283)*1.0821223415669046e-06 + (u_vds - (-0.4997257654908176))*6.904458000334124e-07)/1.6477041649020193e-12;
        if (t < 0.0) t = 0.0; else if (t > 1.0) t = 1.0;
        cx = 0.49990477414668283 + t*1.0821223415669046e-06;
        cy = (-0.4997257654908176) + t*6.904458000334124e-07;
        e = (u_vgs - cx)*(u_vgs - cx) + (u_vds - cy)*(u_vds - cy);
        if (e < best) begin best = e; b_vgs = cx; b_vds = cy; end
        t = ((u_vgs - 0.4999058562690244)*5.717789044790145e-05 + (u_vds - (-0.49972507504501756))*3.6681906501467854e-05)/4.614873420654649e-09;
        if (t < 0.0) t = 0.0; else if (t > 1.0) t = 1.0;
        cx = 0.4999058562690244 + t*5.717789044790145e-05;
        cy = (-0.49972507504501756) + t*3.6681906501467854e-05;
        e = (u_vgs - cx)*(u_vgs - cx) + (u_vds - cy)*(u_vds - cy);
        if (e < best) begin best = e; b_vgs = cx; b_vds = cy; end
        t = ((u_vgs - 0.4999630341594723)*2.2306282936868094e-06 + (u_vds - (-0.4996883931385161))*1.4390628000904293e-06)/7.046604327200234e-12;
        if (t < 0.0) t = 0.0; else if (t > 1.0) t = 1.0;
        cx = 0.4999630341594723 + t*2.2306282936868094e-06;
        cy = (-0.4996883931385161) + t*1.4390628000904293e-06;
        e = (u_vgs - cx)*(u_vgs - cx) + (u_vds - cy)*(u_vds - cy);
        if (e < best) begin best = e; b_vgs = cx; b_vds = cy; end
        t = ((u_vgs - 0.499965264787766)*8.063524681301004e-09 + (u_vds - (-0.499686954075716))*5.211699960483429e-09)/9.218224676405343e-17;
        if (t < 0.0) t = 0.0; else if (t > 1.0) t = 1.0;
        cx = 0.499965264787766 + t*8.063524681301004e-09;
        cy = (-0.499686954075716) + t*5.211699960483429e-09;
        e = (u_vgs - cx)*(u_vgs - cx) + (u_vds - cy)*(u_vds - cy);
        if (e < best) begin best = e; b_vgs = cx; b_vds = cy; end
        t = ((u_vgs - 0.49996527285129067)*3.47271487093348e-05 + (u_vds - (-0.49968694886401605))*2.248287370093527e-05)/1.7114544673324604e-09;
        if (t < 0.0) t = 0.0; else if (t > 1.0) t = 1.0;
        cx = 0.49996527285129067 + t*3.47271487093348e-05;
        cy = (-0.49968694886401605) + t*2.248287370093527e-05;
        e = (u_vgs - cx)*(u_vgs - cx) + (u_vds - cy)*(u_vds - cy);
        if (e < best) begin best = e; b_vgs = cx; b_vds = cy; end
        t = ((u_vgs - 0.5)*(-0.0448694819081929) + (u_vds - (-0.4996644659903151))*0.902239361428042)/0.8160491357167905;
        if (t < 0.0) t = 0.0; else if (t > 1.0) t = 1.0;
        cx = 0.5 + t*(-0.0448694819081929);
        cy = (-0.4996644659903151) + t*0.902239361428042;
        e = (u_vgs - cx)*(u_vgs - cx) + (u_vds - cy)*(u_vds - cy);
        if (e < best) begin best = e; b_vgs = cx; b_vds = cy; end
        t = ((u_vgs - 0.4551305180918071)*(-0.03768579064416239) + (u_vds - 0.40257489543772684)*0.021477665416650416)/0.0018815089282252185;
        if (t < 0.0) t = 0.0; else if (t > 1.0) t = 1.0;
        cx = 0.4551305180918071 + t*(-0.03768579064416239);
        cy = 0.40257489543772684 + t*0.021477665416650416;
        e = (u_vgs - cx)*(u_vgs - cx) + (u_vds - cy)*(u_vds - cy);
        if (e < best) begin best = e; b_vgs = cx; b_vds = cy; end
        t = ((u_vgs - 0.4174447274476447)*(-0.019615004166576355) + (u_vds - 0.42405256085437726)*0.01020836285572968)/0.0004889590606490492;
        if (t < 0.0) t = 0.0; else if (t > 1.0) t = 1.0;
        cx = 0.4174447274476447 + t*(-0.019615004166576355);
        cy = 0.42405256085437726 + t*0.01020836285572968;
        e = (u_vgs - cx)*(u_vgs - cx) + (u_vds - cy)*(u_vds - cy);
        if (e < best) begin best = e; b_vgs = cx; b_vds = cy; end
        t = ((u_vgs - 0.39782972328106836)*(-0.041062772128810765) + (u_vds - 0.43426092371010694)*0.019133815097989837)/0.0020522541351067018;
        if (t < 0.0) t = 0.0; else if (t > 1.0) t = 1.0;
        cx = 0.39782972328106836 + t*(-0.041062772128810765);
        cy = 0.43426092371010694 + t*0.019133815097989837;
        e = (u_vgs - cx)*(u_vgs - cx) + (u_vds - cy)*(u_vds - cy);
        if (e < best) begin best = e; b_vgs = cx; b_vds = cy; end
        t = ((u_vgs - 0.3567669511522576)*(-0.04406744778361449) + (u_vds - 0.4533947388080968)*0.01703046810393727)/0.002231976798000814;
        if (t < 0.0) t = 0.0; else if (t > 1.0) t = 1.0;
        cx = 0.3567669511522576 + t*(-0.04406744778361449);
        cy = 0.4533947388080968 + t*0.01703046810393727;
        e = (u_vgs - cx)*(u_vgs - cx) + (u_vds - cy)*(u_vds - cy);
        if (e < best) begin best = e; b_vgs = cx; b_vds = cy; end
        t = ((u_vgs - 0.3126995033686431)*(-0.048050247752786934) + (u_vds - 0.47042520691203404)*0.014242408137676854)/0.0025116724986643697;
        if (t < 0.0) t = 0.0; else if (t > 1.0) t = 1.0;
        cx = 0.3126995033686431 + t*(-0.048050247752786934);
        cy = 0.47042520691203404 + t*0.014242408137676854;
        e = (u_vgs - cx)*(u_vgs - cx) + (u_vds - cy)*(u_vds - cy);
        if (e < best) begin best = e; b_vgs = cx; b_vds = cy; end
        t = ((u_vgs - 0.26464925561585617)*(-0.0536902534610654) + (u_vds - 0.4846676150497109)*0.010294262547965505)/0.0029886151581198905;
        if (t < 0.0) t = 0.0; else if (t > 1.0) t = 1.0;
        cx = 0.26464925561585617 + t*(-0.0536902534610654);
        cy = 0.4846676150497109 + t*0.010294262547965505;
        e = (u_vgs - cx)*(u_vgs - cx) + (u_vds - cy)*(u_vds - cy);
        if (e < best) begin best = e; b_vgs = cx; b_vds = cy; end
        t = ((u_vgs - 0.21095900215479077)*(-0.0618544357438216) + (u_vds - 0.4949618775976764)*0.004579129985961605)/0.003846939652614888;
        if (t < 0.0) t = 0.0; else if (t > 1.0) t = 1.0;
        cx = 0.21095900215479077 + t*(-0.0618544357438216);
        cy = 0.4949618775976764 + t*0.004579129985961605;
        e = (u_vgs - cx)*(u_vgs - cx) + (u_vds - cy)*(u_vds - cy);
        if (e < best) begin best = e; b_vgs = cx; b_vds = cy; end
        t = ((u_vgs - 0.14910456641096917)*(-0.0677474626858589) + (u_vds - 0.499541007583638)*0.00045386318044982055)/0.0045899246921584135;
        if (t < 0.0) t = 0.0; else if (t > 1.0) t = 1.0;
        cx = 0.14910456641096917 + t*(-0.0677474626858589);
        cy = 0.499541007583638 + t*0.00045386318044982055;
        e = (u_vgs - cx)*(u_vgs - cx) + (u_vds - cy)*(u_vds - cy);
        if (e < best) begin best = e; b_vgs = cx; b_vds = cy; end
        t = ((u_vgs - 0.08135710372511026)*(-0.06838848819212097) + (u_vds - 0.49999487076408783)*5.129232941936124e-06)/0.004676985343512899;
        if (t < 0.0) t = 0.0; else if (t > 1.0) t = 1.0;
        cx = 0.08135710372511026 + t*(-0.06838848819212097);
        cy = 0.49999487076408783 + t*5.129232941936124e-06;
        e = (u_vgs - cx)*(u_vgs - cx) + (u_vds - cy)*(u_vds - cy);
        if (e < best) begin best = e; b_vgs = cx; b_vds = cy; end
        t = ((u_vgs - 0.012968615532989293)*(-0.5129686155329887) + (u_vds - 0.49999999999702976)*2.9702351689309126e-12)/0.26313680052183114;
        if (t < 0.0) t = 0.0; else if (t > 1.0) t = 1.0;
        cx = 0.012968615532989293 + t*(-0.5129686155329887);
        cy = 0.49999999999702976 + t*2.9702351689309126e-12;
        e = (u_vgs - cx)*(u_vgs - cx) + (u_vds - cy)*(u_vds - cy);
        if (e < best) begin best = e; b_vgs = cx; b_vds = cy; end
        t = ((u_vgs - (-0.4999999999999994))*(-6.106226635438361e-16) + (u_vds - 0.5)*(-3.3306690738754696e-16))/4.8379360203007365e-31;
        if (t < 0.0) t = 0.0; else if (t > 1.0) t = 1.0;
        cx = (-0.4999999999999994) + t*(-6.106226635438361e-16);
        cy = 0.5 + t*(-3.3306690738754696e-16);
        e = (u_vgs - cx)*(u_vgs - cx) + (u_vds - cy)*(u_vds - cy);
        if (e < best) begin best = e; b_vgs = cx; b_vds = cy; end
      end
      // the nearest domain point: the point itself inside, else back from normalised coordinates
      if (inside && inbox) begin
        p_vgs = vgs;
        p_vds = vds;
        p_T = T;
      end else begin
        p_vgs = (-2.075844497250043) + 5.848311005851915*b_vgs;
        p_vds = 9.999999999453182 + 19.99999999902244*b_vds;
        p_T = 75.0 + 100.0*b_T;
      end
      fb = f_IgGs(p_vgs, p_vds, p_T, g_vgs, g_vds, g_T);
      x_IgGs = fb + g_vgs*(vgs - p_vgs) + g_vds*(vds - p_vds) + g_T*(T - p_T);
      dist2 = (u_vgs - b_vgs)*(u_vgs - b_vgs) + (u_vds - b_vds)*(u_vds - b_vds) + (u_T - b_T)*(u_T - b_T);
      s = (vgs - p_vgs);
      // the added conductance on the constituent's own branch: ten times the edge's own, floored, capped by G_x
      ga = 10.0*(g_vgs*1.0);
      gl = min(sqrt(ga*ga + (1e-07*Gx_IgGs)*(1e-07*Gx_IgGs)), Gx_IgGs);
      if (dist2 > 0.0) x_IgGs = x_IgGs + (gl/0.05)*s*sqrt(dist2);
    end
  endfunction

  // Core.Constituents.Ig.IgGd (ANN, 2 hidden layers of 8 x 8, Tanh), the current 6.132197822999999e-09*sinh(u) (Transform: Asinh)
  analog function real f_IgGd;
    input vgs, vds, T;
    output d_vgs, d_vds, d_T;
    real vgs, vds, T;
    real d_vgs, d_vds, d_T;
    real z, x1, x2, x3, h1_1, h1_1_vgs, h1_1_vds, h1_1_T, h1_2, h1_2_vgs, h1_2_vds, h1_2_T;
    real h1_3, h1_3_vgs, h1_3_vds, h1_3_T, h1_4, h1_4_vgs, h1_4_vds, h1_4_T, h1_5, h1_5_vgs, h1_5_vds, h1_5_T;
    real h1_6, h1_6_vgs, h1_6_vds, h1_6_T, h1_7, h1_7_vgs, h1_7_vds, h1_7_T, h1_8, h1_8_vgs, h1_8_vds, h1_8_T;
    real h2_1, h2_1_vgs, h2_1_vds, h2_1_T, h2_2, h2_2_vgs, h2_2_vds, h2_2_T, h2_3, h2_3_vgs, h2_3_vds, h2_3_T;
    real h2_4, h2_4_vgs, h2_4_vds, h2_4_T, h2_5, h2_5_vgs, h2_5_vds, h2_5_T, h2_6, h2_6_vgs, h2_6_vds, h2_6_T;
    real h2_7, h2_7_vgs, h2_7_vds, h2_7_T, h2_8, h2_8_vgs, h2_8_vds, h2_8_T, u, u_vgs, u_vds, u_T;
    real w, sh, ch;
    begin
      x1 = (vgs - (-2.075844497250043))*0.3419790770358771;
      x2 = (vds - 9.999999999453182)*0.1000000000048878;
      x3 = (T - 75.0)*0.02;
      // hidden layer 1
      z = -0.5689968146440224 + 0.3469320420559206*x1 + 0.01664657034964129*x2 - 0.0019895832719797374*x3;
      h1_1 = tanh(z);
      h1_1_vgs = (1.0 - h1_1*h1_1)*(0.11864349953645582);
      h1_1_vds = (1.0 - h1_1*h1_1)*(0.0016646570350454942);
      h1_1_T = (1.0 - h1_1*h1_1)*(-3.979166543959475e-05);
      z = -4.636683055228568 + 1.005803958181252*x1 + 2.2102796787800822*x2 - 0.023401002634653924*x3;
      h1_2 = tanh(z);
      h1_2_vgs = (1.0 - h1_2*h1_2)*(0.3439639092978565);
      h1_2_vds = (1.0 - h1_2*h1_2)*(0.22102796788881163);
      h1_2_T = (1.0 - h1_2*h1_2)*(-0.0004680200526930785);
      z = -1.971850283230253 + 0.471647320499474*x1 + 0.5877858820314216*x2 - 0.27806086123063783*x3;
      h1_3 = tanh(z);
      h1_3_vgs = (1.0 - h1_3*h1_3)*(0.16129351535085462);
      h1_3_vds = (1.0 - h1_3*h1_3)*(0.05877858820601514);
      h1_3_T = (1.0 - h1_3*h1_3)*(-0.005561217224612757);
      z = 5.312923949186388 - 7.343128668199695*x1 - 0.11985533701441993*x2 + 0.0017917528808594463*x3;
      h1_4 = tanh(z);
      h1_4_vgs = (1.0 - h1_4*h1_4)*(-2.511196364506621);
      h1_4_vds = (1.0 - h1_4*h1_4)*(-0.011985533702027823);
      h1_4_T = (1.0 - h1_4*h1_4)*(3.5835057617188925e-05);
      z = -3.3174480224597342 + 0.9793138955590478*x1 + 0.11723677621688315*x2 - 0.30244663283893236*x3;
      h1_5 = tanh(z);
      h1_5_vgs = (1.0 - h1_5*h1_5)*(0.3349048621316925);
      h1_5_vds = (1.0 - h1_5*h1_5)*(0.011723677622261345);
      h1_5_T = (1.0 - h1_5*h1_5)*(-0.006048932656778647);
      z = 5.738121353340034 - 3.9807408779450193*x1 + 0.7842430112321694*x2 - 0.06927751095131095*x3;
      h1_6 = tanh(z);
      h1_6_vgs = (1.0 - h1_6*h1_6)*(-1.3613300913586248);
      h1_6_vds = (1.0 - h1_6*h1_6)*(0.07842430112705016);
      h1_6_T = (1.0 - h1_6*h1_6)*(-0.001385550219026219);
      z = -9.368573367632234 + 0.026786103673813743*x1 - 8.981929819608848*x2 - 0.006774364683432553*x3;
      h1_7 = tanh(z);
      h1_7_vgs = (1.0 - h1_7*h1_7)*(0.009160287011758141);
      h1_7_vds = (1.0 - h1_7*h1_7)*(-0.8981929820047867);
      h1_7_T = (1.0 - h1_7*h1_7)*(-0.00013548729366865108);
      z = 0.6960960099344501 - 0.09382476230490304*x1 + 0.44044786608879455*x2 - 0.03358201475726044*x3;
      h1_8 = tanh(z);
      h1_8_vgs = (1.0 - h1_8*h1_8)*(-0.032086105616141294);
      h1_8_vds = (1.0 - h1_8*h1_8)*(0.044044786611032276);
      h1_8_T = (1.0 - h1_8*h1_8)*(-0.0006716402951452089);
      // hidden layer 2
      z = 3.2559956496827684 + 0.2975502835938175*h1_1 - 1.566140027854781*h1_2 + 0.8769018626980587*h1_3 - 0.15248517420819727*h1_4 - 0.4893123124035011*h1_5 + 0.6435503718944422*h1_6 - 0.8225556362051444*h1_7 - 0.11864547024104252*h1_8;
      h2_1 = tanh(z);
      h2_1_vgs = (1.0 - h2_1*h2_1)*(0.2975502835938175*h1_1_vgs - 1.566140027854781*h1_2_vgs + 0.8769018626980587*h1_3_vgs - 0.15248517420819727*h1_4_vgs - 0.4893123124035011*h1_5_vgs + 0.6435503718944422*h1_6_vgs - 0.8225556362051444*h1_7_vgs - 0.11864547024104252*h1_8_vgs);
      h2_1_vds = (1.0 - h2_1*h2_1)*(0.2975502835938175*h1_1_vds - 1.566140027854781*h1_2_vds + 0.8769018626980587*h1_3_vds - 0.15248517420819727*h1_4_vds - 0.4893123124035011*h1_5_vds + 0.6435503718944422*h1_6_vds - 0.8225556362051444*h1_7_vds - 0.11864547024104252*h1_8_vds);
      h2_1_T = (1.0 - h2_1*h2_1)*(0.2975502835938175*h1_1_T - 1.566140027854781*h1_2_T + 0.8769018626980587*h1_3_T - 0.15248517420819727*h1_4_T - 0.4893123124035011*h1_5_T + 0.6435503718944422*h1_6_T - 0.8225556362051444*h1_7_T - 0.11864547024104252*h1_8_T);
      z = 0.42777727412073885 - 2.440532153725718*h1_1 + 0.3849365489137997*h1_2 + 1.3668993477660716*h1_3 + 8.110482045365458*h1_4 + 0.7894963550070957*h1_5 - 0.5643416185584582*h1_6 + 1.0666396633718902*h1_7 + 0.5789685053483274*h1_8;
      h2_2 = tanh(z);
      h2_2_vgs = (1.0 - h2_2*h2_2)*(- 2.440532153725718*h1_1_vgs + 0.3849365489137997*h1_2_vgs + 1.3668993477660716*h1_3_vgs + 8.110482045365458*h1_4_vgs + 0.7894963550070957*h1_5_vgs - 0.5643416185584582*h1_6_vgs + 1.0666396633718902*h1_7_vgs + 0.5789685053483274*h1_8_vgs);
      h2_2_vds = (1.0 - h2_2*h2_2)*(- 2.440532153725718*h1_1_vds + 0.3849365489137997*h1_2_vds + 1.3668993477660716*h1_3_vds + 8.110482045365458*h1_4_vds + 0.7894963550070957*h1_5_vds - 0.5643416185584582*h1_6_vds + 1.0666396633718902*h1_7_vds + 0.5789685053483274*h1_8_vds);
      h2_2_T = (1.0 - h2_2*h2_2)*(- 2.440532153725718*h1_1_T + 0.3849365489137997*h1_2_T + 1.3668993477660716*h1_3_T + 8.110482045365458*h1_4_T + 0.7894963550070957*h1_5_T - 0.5643416185584582*h1_6_T + 1.0666396633718902*h1_7_T + 0.5789685053483274*h1_8_T);
      z = 2.3074499538902646 - 1.2009397572644094*h1_1 + 1.3548779440326078*h1_2 - 0.31010442153080753*h1_3 - 0.8906030289420288*h1_4 - 1.1562683194960788*h1_5 + 6.374349062710274*h1_6 + 2.120342225475062*h1_7 - 0.5871209160084884*h1_8;
      h2_3 = tanh(z);
      h2_3_vgs = (1.0 - h2_3*h2_3)*(- 1.2009397572644094*h1_1_vgs + 1.3548779440326078*h1_2_vgs - 0.31010442153080753*h1_3_vgs - 0.8906030289420288*h1_4_vgs - 1.1562683194960788*h1_5_vgs + 6.374349062710274*h1_6_vgs + 2.120342225475062*h1_7_vgs - 0.5871209160084884*h1_8_vgs);
      h2_3_vds = (1.0 - h2_3*h2_3)*(- 1.2009397572644094*h1_1_vds + 1.3548779440326078*h1_2_vds - 0.31010442153080753*h1_3_vds - 0.8906030289420288*h1_4_vds - 1.1562683194960788*h1_5_vds + 6.374349062710274*h1_6_vds + 2.120342225475062*h1_7_vds - 0.5871209160084884*h1_8_vds);
      h2_3_T = (1.0 - h2_3*h2_3)*(- 1.2009397572644094*h1_1_T + 1.3548779440326078*h1_2_T - 0.31010442153080753*h1_3_T - 0.8906030289420288*h1_4_T - 1.1562683194960788*h1_5_T + 6.374349062710274*h1_6_T + 2.120342225475062*h1_7_T - 0.5871209160084884*h1_8_T);
      z = -0.45319181712951295 + 0.9466206201717233*h1_1 + 1.2290040750199085*h1_2 + 0.9540336620807042*h1_3 + 0.19500436773538707*h1_4 + 0.5279084804553925*h1_5 - 2.957297781281373*h1_6 - 1.3069970853289785*h1_7 + 0.7418607157772148*h1_8;
      h2_4 = tanh(z);
      h2_4_vgs = (1.0 - h2_4*h2_4)*(0.9466206201717233*h1_1_vgs + 1.2290040750199085*h1_2_vgs + 0.9540336620807042*h1_3_vgs + 0.19500436773538707*h1_4_vgs + 0.5279084804553925*h1_5_vgs - 2.957297781281373*h1_6_vgs - 1.3069970853289785*h1_7_vgs + 0.7418607157772148*h1_8_vgs);
      h2_4_vds = (1.0 - h2_4*h2_4)*(0.9466206201717233*h1_1_vds + 1.2290040750199085*h1_2_vds + 0.9540336620807042*h1_3_vds + 0.19500436773538707*h1_4_vds + 0.5279084804553925*h1_5_vds - 2.957297781281373*h1_6_vds - 1.3069970853289785*h1_7_vds + 0.7418607157772148*h1_8_vds);
      h2_4_T = (1.0 - h2_4*h2_4)*(0.9466206201717233*h1_1_T + 1.2290040750199085*h1_2_T + 0.9540336620807042*h1_3_T + 0.19500436773538707*h1_4_T + 0.5279084804553925*h1_5_T - 2.957297781281373*h1_6_T - 1.3069970853289785*h1_7_T + 0.7418607157772148*h1_8_T);
      z = 0.07524750708536716 - 1.4307310893743614*h1_1 - 0.5633355865186946*h1_2 - 0.5180210692178331*h1_3 - 1.3495772151990706*h1_4 + 0.2626399112428607*h1_5 + 0.5781819965878908*h1_6 + 0.046146087371171415*h1_7 + 0.22446038734909596*h1_8;
      h2_5 = tanh(z);
      h2_5_vgs = (1.0 - h2_5*h2_5)*(- 1.4307310893743614*h1_1_vgs - 0.5633355865186946*h1_2_vgs - 0.5180210692178331*h1_3_vgs - 1.3495772151990706*h1_4_vgs + 0.2626399112428607*h1_5_vgs + 0.5781819965878908*h1_6_vgs + 0.046146087371171415*h1_7_vgs + 0.22446038734909596*h1_8_vgs);
      h2_5_vds = (1.0 - h2_5*h2_5)*(- 1.4307310893743614*h1_1_vds - 0.5633355865186946*h1_2_vds - 0.5180210692178331*h1_3_vds - 1.3495772151990706*h1_4_vds + 0.2626399112428607*h1_5_vds + 0.5781819965878908*h1_6_vds + 0.046146087371171415*h1_7_vds + 0.22446038734909596*h1_8_vds);
      h2_5_T = (1.0 - h2_5*h2_5)*(- 1.4307310893743614*h1_1_T - 0.5633355865186946*h1_2_T - 0.5180210692178331*h1_3_T - 1.3495772151990706*h1_4_T + 0.2626399112428607*h1_5_T + 0.5781819965878908*h1_6_T + 0.046146087371171415*h1_7_T + 0.22446038734909596*h1_8_T);
      z = 0.46410739995349976 - 1.9135073365495556*h1_1 + 0.679970962653414*h1_2 + 0.1569583434955823*h1_3 + 1.365978204342144*h1_4 + 0.5410566393271107*h1_5 - 2.3959757654706992*h1_6 + 0.002966415336810368*h1_7 + 0.029107125826281888*h1_8;
      h2_6 = tanh(z);
      h2_6_vgs = (1.0 - h2_6*h2_6)*(- 1.9135073365495556*h1_1_vgs + 0.679970962653414*h1_2_vgs + 0.1569583434955823*h1_3_vgs + 1.365978204342144*h1_4_vgs + 0.5410566393271107*h1_5_vgs - 2.3959757654706992*h1_6_vgs + 0.002966415336810368*h1_7_vgs + 0.029107125826281888*h1_8_vgs);
      h2_6_vds = (1.0 - h2_6*h2_6)*(- 1.9135073365495556*h1_1_vds + 0.679970962653414*h1_2_vds + 0.1569583434955823*h1_3_vds + 1.365978204342144*h1_4_vds + 0.5410566393271107*h1_5_vds - 2.3959757654706992*h1_6_vds + 0.002966415336810368*h1_7_vds + 0.029107125826281888*h1_8_vds);
      h2_6_T = (1.0 - h2_6*h2_6)*(- 1.9135073365495556*h1_1_T + 0.679970962653414*h1_2_T + 0.1569583434955823*h1_3_T + 1.365978204342144*h1_4_T + 0.5410566393271107*h1_5_T - 2.3959757654706992*h1_6_T + 0.002966415336810368*h1_7_T + 0.029107125826281888*h1_8_T);
      z = -0.6038786529537855 - 3.619890496478763*h1_1 + 2.5630082357937964*h1_2 + 0.571445060553892*h1_3 + 0.9005233538466609*h1_4 + 0.04754457463701507*h1_5 + 3.2086219472697795*h1_6 + 8.742331456604031*h1_7 - 1.6039248007795976*h1_8;
      h2_7 = tanh(z);
      h2_7_vgs = (1.0 - h2_7*h2_7)*(- 3.619890496478763*h1_1_vgs + 2.5630082357937964*h1_2_vgs + 0.571445060553892*h1_3_vgs + 0.9005233538466609*h1_4_vgs + 0.04754457463701507*h1_5_vgs + 3.2086219472697795*h1_6_vgs + 8.742331456604031*h1_7_vgs - 1.6039248007795976*h1_8_vgs);
      h2_7_vds = (1.0 - h2_7*h2_7)*(- 3.619890496478763*h1_1_vds + 2.5630082357937964*h1_2_vds + 0.571445060553892*h1_3_vds + 0.9005233538466609*h1_4_vds + 0.04754457463701507*h1_5_vds + 3.2086219472697795*h1_6_vds + 8.742331456604031*h1_7_vds - 1.6039248007795976*h1_8_vds);
      h2_7_T = (1.0 - h2_7*h2_7)*(- 3.619890496478763*h1_1_T + 2.5630082357937964*h1_2_T + 0.571445060553892*h1_3_T + 0.9005233538466609*h1_4_T + 0.04754457463701507*h1_5_T + 3.2086219472697795*h1_6_T + 8.742331456604031*h1_7_T - 1.6039248007795976*h1_8_T);
      z = 1.5345890662954564 - 0.9991626337283289*h1_1 - 1.4563490847754321*h1_2 - 0.6642334659186269*h1_3 - 0.08592426874250196*h1_4 - 0.06942343734875613*h1_5 - 0.7002810200555053*h1_6 - 0.8754583502680225*h1_7 - 0.6968826224305633*h1_8;
      h2_8 = tanh(z);
      h2_8_vgs = (1.0 - h2_8*h2_8)*(- 0.9991626337283289*h1_1_vgs - 1.4563490847754321*h1_2_vgs - 0.6642334659186269*h1_3_vgs - 0.08592426874250196*h1_4_vgs - 0.06942343734875613*h1_5_vgs - 0.7002810200555053*h1_6_vgs - 0.8754583502680225*h1_7_vgs - 0.6968826224305633*h1_8_vgs);
      h2_8_vds = (1.0 - h2_8*h2_8)*(- 0.9991626337283289*h1_1_vds - 1.4563490847754321*h1_2_vds - 0.6642334659186269*h1_3_vds - 0.08592426874250196*h1_4_vds - 0.06942343734875613*h1_5_vds - 0.7002810200555053*h1_6_vds - 0.8754583502680225*h1_7_vds - 0.6968826224305633*h1_8_vds);
      h2_8_T = (1.0 - h2_8*h2_8)*(- 0.9991626337283289*h1_1_T - 1.4563490847754321*h1_2_T - 0.6642334659186269*h1_3_T - 0.08592426874250196*h1_4_T - 0.06942343734875613*h1_5_T - 0.7002810200555053*h1_6_T - 0.8754583502680225*h1_7_T - 0.6968826224305633*h1_8_T);
      // output
      u = 3.3417968794791744 - 0.439016735897763*h2_1 - 0.10021590233370052*h2_2 + 3.6850086894912266*h2_3 + 1.3318096369648806*h2_4 - 0.9473895685119558*h2_5 - 3.8228012942997447*h2_6 + 8.178449373727638*h2_7 + 0.9456627299405168*h2_8;
      u_vgs = - 0.439016735897763*h2_1_vgs - 0.10021590233370052*h2_2_vgs + 3.6850086894912266*h2_3_vgs + 1.3318096369648806*h2_4_vgs - 0.9473895685119558*h2_5_vgs - 3.8228012942997447*h2_6_vgs + 8.178449373727638*h2_7_vgs + 0.9456627299405168*h2_8_vgs;
      u_vds = - 0.439016735897763*h2_1_vds - 0.10021590233370052*h2_2_vds + 3.6850086894912266*h2_3_vds + 1.3318096369648806*h2_4_vds - 0.9473895685119558*h2_5_vds - 3.8228012942997447*h2_6_vds + 8.178449373727638*h2_7_vds + 0.9456627299405168*h2_8_vds;
      u_T = - 0.439016735897763*h2_1_T - 0.10021590233370052*h2_2_T + 3.6850086894912266*h2_3_T + 1.3318096369648806*h2_4_T - 0.9473895685119558*h2_5_T - 3.8228012942997447*h2_6_T + 8.178449373727638*h2_7_T + 0.9456627299405168*h2_8_T;
      w = (-0.0013861335336109691) + 0.0013861335336109691*u;
      sh = 6.132197822999999e-09*sinh(w);
      ch = 6.132197822999999e-09*cosh(w);
      f_IgGd = sh;
      d_vgs = (0.0013861335336109691*u_vgs)*ch;
      d_vds = (0.0013861335336109691*u_vds)*ch;
      d_T = (0.0013861335336109691*u_T)*ch;
    end
  endfunction

  // Core.Constituents.Ig.IgGd continued outside Core.Constituents.Ig.Domain (guided extrapolation)
  analog function real x_IgGd;
    input vgs, vds, T;
    real vgs, vds, T;
    real u_vgs, u_vds, u_T, b_vgs, b_vds, b_T, p_vgs, p_vds, p_T, g_vgs, g_vds, g_T;
    real t, cx, cy, e, best, cr, fb, s, dist2, gl, ga;
    integer inside, inbox;
    begin
      // normalised by the domain's centre and extent
      u_vgs = (vgs - (-2.075844497250043))/5.848311005851915;
      u_vds = (vds - 9.999999999453182)/19.99999999902244;
      u_T = (T - 75.0)/100.0;
      inbox = 1;
      // Domain.Box.T
      if (u_T < (-0.5)) begin b_T = (-0.5); inbox = 0; end
      else if (u_T > 0.5) begin b_T = 0.5; inbox = 0; end
      else b_T = u_T;
      // Domain.Polygon: 27 vertices, counter-clockwise
      inside = 1;
      cr = 1.3542333920923966e-11*(u_vds - 0.49999999999999967) - (-0.19999999999845564)*(u_vgs - (-0.5));
      if (cr < 0.0) inside = 0;
      cr = 3.3856029091339224e-11*(u_vds - 0.30000000000154403) - (-0.49999999999613887)*(u_vgs - (-0.49999999998645767));
      if (cr < 0.0) inside = 0;
      cr = 1.6928125567972074e-11*(u_vds - (-0.19999999999459486)) - (-0.2499999999980694)*(u_vgs - (-0.49999999995260164));
      if (cr < 0.0) inside = 0;
      cr = 1.6928680679484387e-12*(u_vds - (-0.44999999999266427)) - (-0.0249999999998069)*(u_vgs - (-0.4999999999356735));
      if (cr < 0.0) inside = 0;
      cr = 4.2935932587084835e-10*(u_vds - (-0.47499999999247117)) - (-0.025000000007528833)*(u_vgs - (-0.49999999993398064));
      if (cr < 0.0) inside = 0;
      cr = 0.9233435074941116*(u_vds - (-0.5)) - 2.9594104944408173e-12*(u_vgs - (-0.4999999995046213));
      if (cr < 0.0) inside = 0;
      cr = 0.034113794764288774*(u_vds - (-0.4999999999970406)) - 5.829473690988074e-07*(u_vgs - 0.42334350798949033);
      if (cr < 0.0) inside = 0;
      cr = 0.026864822980150194*(u_vds - (-0.4999994170496715)) - 4.079733367262639e-05*(u_vgs - 0.4574573027537791);
      if (cr < 0.0) inside = 0;
      cr = 0.009015630415252218*(u_vds - (-0.49995861971599886)) - 9.970040023588034e-05*(u_vgs - 0.4843221257339293);
      if (cr < 0.0) inside = 0;
      cr = 0.006567017997501312*(u_vds - (-0.499858919315763)) - 0.00013315382494538675*(u_vgs - 0.4933377561491815);
      if (cr < 0.0) inside = 0;
      cr = 1.0821223415669046e-06*(u_vds - (-0.4997257654908176)) - 6.904458000334124e-07*(u_vgs - 0.49990477414668283);
      if (cr < 0.0) inside = 0;
      cr = 5.717789044790145e-05*(u_vds - (-0.49972507504501756)) - 3.6681906501467854e-05*(u_vgs - 0.4999058562690244);
      if (cr < 0.0) inside = 0;
      cr = 2.2306282936868094e-06*(u_vds - (-0.4996883931385161)) - 1.4390628000904293e-06*(u_vgs - 0.4999630341594723);
      if (cr < 0.0) inside = 0;
      cr = 8.063524681301004e-09*(u_vds - (-0.499686954075716)) - 5.211699960483429e-09*(u_vgs - 0.499965264787766);
      if (cr < 0.0) inside = 0;
      cr = 3.47271487093348e-05*(u_vds - (-0.49968694886401605)) - 2.248287370093527e-05*(u_vgs - 0.49996527285129067);
      if (cr < 0.0) inside = 0;
      cr = (-0.0448694819081929)*(u_vds - (-0.4996644659903151)) - 0.902239361428042*(u_vgs - 0.5);
      if (cr < 0.0) inside = 0;
      cr = (-0.03768579064416239)*(u_vds - 0.40257489543772684) - 0.021477665416650416*(u_vgs - 0.4551305180918071);
      if (cr < 0.0) inside = 0;
      cr = (-0.019615004166576355)*(u_vds - 0.42405256085437726) - 0.01020836285572968*(u_vgs - 0.4174447274476447);
      if (cr < 0.0) inside = 0;
      cr = (-0.041062772128810765)*(u_vds - 0.43426092371010694) - 0.019133815097989837*(u_vgs - 0.39782972328106836);
      if (cr < 0.0) inside = 0;
      cr = (-0.04406744778361449)*(u_vds - 0.4533947388080968) - 0.01703046810393727*(u_vgs - 0.3567669511522576);
      if (cr < 0.0) inside = 0;
      cr = (-0.048050247752786934)*(u_vds - 0.47042520691203404) - 0.014242408137676854*(u_vgs - 0.3126995033686431);
      if (cr < 0.0) inside = 0;
      cr = (-0.0536902534610654)*(u_vds - 0.4846676150497109) - 0.010294262547965505*(u_vgs - 0.26464925561585617);
      if (cr < 0.0) inside = 0;
      cr = (-0.0618544357438216)*(u_vds - 0.4949618775976764) - 0.004579129985961605*(u_vgs - 0.21095900215479077);
      if (cr < 0.0) inside = 0;
      cr = (-0.0677474626858589)*(u_vds - 0.499541007583638) - 0.00045386318044982055*(u_vgs - 0.14910456641096917);
      if (cr < 0.0) inside = 0;
      cr = (-0.06838848819212097)*(u_vds - 0.49999487076408783) - 5.129232941936124e-06*(u_vgs - 0.08135710372511026);
      if (cr < 0.0) inside = 0;
      cr = (-0.5129686155329887)*(u_vds - 0.49999999999702976) - 2.9702351689309126e-12*(u_vgs - 0.012968615532989293);
      if (cr < 0.0) inside = 0;
      cr = (-6.106226635438361e-16)*(u_vds - 0.5) - (-3.3306690738754696e-16)*(u_vgs - (-0.4999999999999994));
      if (cr < 0.0) inside = 0;
      if (inside) begin
        b_vgs = u_vgs;
        b_vds = u_vds;
      end else begin
        t = ((u_vgs - (-0.5))*1.3542333920923966e-11 + (u_vds - 0.49999999999999967)*(-0.19999999999845564))/0.03999999999938225;
        if (t < 0.0) t = 0.0; else if (t > 1.0) t = 1.0;
        cx = (-0.5) + t*1.3542333920923966e-11;
        cy = 0.49999999999999967 + t*(-0.19999999999845564);
        e = (u_vgs - cx)*(u_vgs - cx) + (u_vds - cy)*(u_vds - cy);
        best = e; b_vgs = cx; b_vds = cy;
        t = ((u_vgs - (-0.49999999998645767))*3.3856029091339224e-11 + (u_vds - 0.30000000000154403)*(-0.49999999999613887))/0.24999999999613887;
        if (t < 0.0) t = 0.0; else if (t > 1.0) t = 1.0;
        cx = (-0.49999999998645767) + t*3.3856029091339224e-11;
        cy = 0.30000000000154403 + t*(-0.49999999999613887);
        e = (u_vgs - cx)*(u_vgs - cx) + (u_vds - cy)*(u_vds - cy);
        if (e < best) begin best = e; b_vgs = cx; b_vds = cy; end
        t = ((u_vgs - (-0.49999999995260164))*1.6928125567972074e-11 + (u_vds - (-0.19999999999459486))*(-0.2499999999980694))/0.0624999999990347;
        if (t < 0.0) t = 0.0; else if (t > 1.0) t = 1.0;
        cx = (-0.49999999995260164) + t*1.6928125567972074e-11;
        cy = (-0.19999999999459486) + t*(-0.2499999999980694);
        e = (u_vgs - cx)*(u_vgs - cx) + (u_vds - cy)*(u_vds - cy);
        if (e < best) begin best = e; b_vgs = cx; b_vds = cy; end
        t = ((u_vgs - (-0.4999999999356735))*1.6928680679484387e-12 + (u_vds - (-0.44999999999266427))*(-0.0249999999998069))/0.000624999999990345;
        if (t < 0.0) t = 0.0; else if (t > 1.0) t = 1.0;
        cx = (-0.4999999999356735) + t*1.6928680679484387e-12;
        cy = (-0.44999999999266427) + t*(-0.0249999999998069);
        e = (u_vgs - cx)*(u_vgs - cx) + (u_vds - cy)*(u_vds - cy);
        if (e < best) begin best = e; b_vgs = cx; b_vds = cy; end
        t = ((u_vgs - (-0.49999999993398064))*4.2935932587084835e-10 + (u_vds - (-0.47499999999247117))*(-0.025000000007528833))/0.0006250000003764418;
        if (t < 0.0) t = 0.0; else if (t > 1.0) t = 1.0;
        cx = (-0.49999999993398064) + t*4.2935932587084835e-10;
        cy = (-0.47499999999247117) + t*(-0.025000000007528833);
        e = (u_vgs - cx)*(u_vgs - cx) + (u_vds - cy)*(u_vds - cy);
        if (e < best) begin best = e; b_vgs = cx; b_vds = cy; end
        t = ((u_vgs - (-0.4999999995046213))*0.9233435074941116 + (u_vds - (-0.5))*2.9594104944408173e-12)/0.8525632328315286;
        if (t < 0.0) t = 0.0; else if (t > 1.0) t = 1.0;
        cx = (-0.4999999995046213) + t*0.9233435074941116;
        cy = (-0.5) + t*2.9594104944408173e-12;
        e = (u_vgs - cx)*(u_vgs - cx) + (u_vds - cy)*(u_vds - cy);
        if (e < best) begin best = e; b_vgs = cx; b_vds = cy; end
        t = ((u_vgs - 0.42334350798949033)*0.034113794764288774 + (u_vds - (-0.4999999999970406))*5.829473690988074e-07)/0.0011637509935598436;
        if (t < 0.0) t = 0.0; else if (t > 1.0) t = 1.0;
        cx = 0.42334350798949033 + t*0.034113794764288774;
        cy = (-0.4999999999970406) + t*5.829473690988074e-07;
        e = (u_vgs - cx)*(u_vgs - cx) + (u_vds - cy)*(u_vds - cy);
        if (e < best) begin best = e; b_vgs = cx; b_vds = cy; end
        t = ((u_vgs - 0.4574573027537791)*0.026864822980150194 + (u_vds - (-0.4999994170496715))*4.079733367262639e-05)/0.0007217203781772407;
        if (t < 0.0) t = 0.0; else if (t > 1.0) t = 1.0;
        cx = 0.4574573027537791 + t*0.026864822980150194;
        cy = (-0.4999994170496715) + t*4.079733367262639e-05;
        e = (u_vgs - cx)*(u_vgs - cx) + (u_vds - cy)*(u_vds - cy);
        if (e < best) begin best = e; b_vgs = cx; b_vds = cy; end
        t = ((u_vgs - 0.4843221257339293)*0.009015630415252218 + (u_vds - (-0.49995861971599886))*9.970040023588034e-05)/8.129153195422808e-05;
        if (t < 0.0) t = 0.0; else if (t > 1.0) t = 1.0;
        cx = 0.4843221257339293 + t*0.009015630415252218;
        cy = (-0.49995861971599886) + t*9.970040023588034e-05;
        e = (u_vgs - cx)*(u_vgs - cx) + (u_vds - cy)*(u_vds - cy);
        if (e < best) begin best = e; b_vgs = cx; b_vds = cy; end
        t = ((u_vgs - 0.4933377561491815)*0.006567017997501312 + (u_vds - (-0.499858919315763))*0.00013315382494538675)/4.314345532060373e-05;
        if (t < 0.0) t = 0.0; else if (t > 1.0) t = 1.0;
        cx = 0.4933377561491815 + t*0.006567017997501312;
        cy = (-0.499858919315763) + t*0.00013315382494538675;
        e = (u_vgs - cx)*(u_vgs - cx) + (u_vds - cy)*(u_vds - cy);
        if (e < best) begin best = e; b_vgs = cx; b_vds = cy; end
        t = ((u_vgs - 0.49990477414668283)*1.0821223415669046e-06 + (u_vds - (-0.4997257654908176))*6.904458000334124e-07)/1.6477041649020193e-12;
        if (t < 0.0) t = 0.0; else if (t > 1.0) t = 1.0;
        cx = 0.49990477414668283 + t*1.0821223415669046e-06;
        cy = (-0.4997257654908176) + t*6.904458000334124e-07;
        e = (u_vgs - cx)*(u_vgs - cx) + (u_vds - cy)*(u_vds - cy);
        if (e < best) begin best = e; b_vgs = cx; b_vds = cy; end
        t = ((u_vgs - 0.4999058562690244)*5.717789044790145e-05 + (u_vds - (-0.49972507504501756))*3.6681906501467854e-05)/4.614873420654649e-09;
        if (t < 0.0) t = 0.0; else if (t > 1.0) t = 1.0;
        cx = 0.4999058562690244 + t*5.717789044790145e-05;
        cy = (-0.49972507504501756) + t*3.6681906501467854e-05;
        e = (u_vgs - cx)*(u_vgs - cx) + (u_vds - cy)*(u_vds - cy);
        if (e < best) begin best = e; b_vgs = cx; b_vds = cy; end
        t = ((u_vgs - 0.4999630341594723)*2.2306282936868094e-06 + (u_vds - (-0.4996883931385161))*1.4390628000904293e-06)/7.046604327200234e-12;
        if (t < 0.0) t = 0.0; else if (t > 1.0) t = 1.0;
        cx = 0.4999630341594723 + t*2.2306282936868094e-06;
        cy = (-0.4996883931385161) + t*1.4390628000904293e-06;
        e = (u_vgs - cx)*(u_vgs - cx) + (u_vds - cy)*(u_vds - cy);
        if (e < best) begin best = e; b_vgs = cx; b_vds = cy; end
        t = ((u_vgs - 0.499965264787766)*8.063524681301004e-09 + (u_vds - (-0.499686954075716))*5.211699960483429e-09)/9.218224676405343e-17;
        if (t < 0.0) t = 0.0; else if (t > 1.0) t = 1.0;
        cx = 0.499965264787766 + t*8.063524681301004e-09;
        cy = (-0.499686954075716) + t*5.211699960483429e-09;
        e = (u_vgs - cx)*(u_vgs - cx) + (u_vds - cy)*(u_vds - cy);
        if (e < best) begin best = e; b_vgs = cx; b_vds = cy; end
        t = ((u_vgs - 0.49996527285129067)*3.47271487093348e-05 + (u_vds - (-0.49968694886401605))*2.248287370093527e-05)/1.7114544673324604e-09;
        if (t < 0.0) t = 0.0; else if (t > 1.0) t = 1.0;
        cx = 0.49996527285129067 + t*3.47271487093348e-05;
        cy = (-0.49968694886401605) + t*2.248287370093527e-05;
        e = (u_vgs - cx)*(u_vgs - cx) + (u_vds - cy)*(u_vds - cy);
        if (e < best) begin best = e; b_vgs = cx; b_vds = cy; end
        t = ((u_vgs - 0.5)*(-0.0448694819081929) + (u_vds - (-0.4996644659903151))*0.902239361428042)/0.8160491357167905;
        if (t < 0.0) t = 0.0; else if (t > 1.0) t = 1.0;
        cx = 0.5 + t*(-0.0448694819081929);
        cy = (-0.4996644659903151) + t*0.902239361428042;
        e = (u_vgs - cx)*(u_vgs - cx) + (u_vds - cy)*(u_vds - cy);
        if (e < best) begin best = e; b_vgs = cx; b_vds = cy; end
        t = ((u_vgs - 0.4551305180918071)*(-0.03768579064416239) + (u_vds - 0.40257489543772684)*0.021477665416650416)/0.0018815089282252185;
        if (t < 0.0) t = 0.0; else if (t > 1.0) t = 1.0;
        cx = 0.4551305180918071 + t*(-0.03768579064416239);
        cy = 0.40257489543772684 + t*0.021477665416650416;
        e = (u_vgs - cx)*(u_vgs - cx) + (u_vds - cy)*(u_vds - cy);
        if (e < best) begin best = e; b_vgs = cx; b_vds = cy; end
        t = ((u_vgs - 0.4174447274476447)*(-0.019615004166576355) + (u_vds - 0.42405256085437726)*0.01020836285572968)/0.0004889590606490492;
        if (t < 0.0) t = 0.0; else if (t > 1.0) t = 1.0;
        cx = 0.4174447274476447 + t*(-0.019615004166576355);
        cy = 0.42405256085437726 + t*0.01020836285572968;
        e = (u_vgs - cx)*(u_vgs - cx) + (u_vds - cy)*(u_vds - cy);
        if (e < best) begin best = e; b_vgs = cx; b_vds = cy; end
        t = ((u_vgs - 0.39782972328106836)*(-0.041062772128810765) + (u_vds - 0.43426092371010694)*0.019133815097989837)/0.0020522541351067018;
        if (t < 0.0) t = 0.0; else if (t > 1.0) t = 1.0;
        cx = 0.39782972328106836 + t*(-0.041062772128810765);
        cy = 0.43426092371010694 + t*0.019133815097989837;
        e = (u_vgs - cx)*(u_vgs - cx) + (u_vds - cy)*(u_vds - cy);
        if (e < best) begin best = e; b_vgs = cx; b_vds = cy; end
        t = ((u_vgs - 0.3567669511522576)*(-0.04406744778361449) + (u_vds - 0.4533947388080968)*0.01703046810393727)/0.002231976798000814;
        if (t < 0.0) t = 0.0; else if (t > 1.0) t = 1.0;
        cx = 0.3567669511522576 + t*(-0.04406744778361449);
        cy = 0.4533947388080968 + t*0.01703046810393727;
        e = (u_vgs - cx)*(u_vgs - cx) + (u_vds - cy)*(u_vds - cy);
        if (e < best) begin best = e; b_vgs = cx; b_vds = cy; end
        t = ((u_vgs - 0.3126995033686431)*(-0.048050247752786934) + (u_vds - 0.47042520691203404)*0.014242408137676854)/0.0025116724986643697;
        if (t < 0.0) t = 0.0; else if (t > 1.0) t = 1.0;
        cx = 0.3126995033686431 + t*(-0.048050247752786934);
        cy = 0.47042520691203404 + t*0.014242408137676854;
        e = (u_vgs - cx)*(u_vgs - cx) + (u_vds - cy)*(u_vds - cy);
        if (e < best) begin best = e; b_vgs = cx; b_vds = cy; end
        t = ((u_vgs - 0.26464925561585617)*(-0.0536902534610654) + (u_vds - 0.4846676150497109)*0.010294262547965505)/0.0029886151581198905;
        if (t < 0.0) t = 0.0; else if (t > 1.0) t = 1.0;
        cx = 0.26464925561585617 + t*(-0.0536902534610654);
        cy = 0.4846676150497109 + t*0.010294262547965505;
        e = (u_vgs - cx)*(u_vgs - cx) + (u_vds - cy)*(u_vds - cy);
        if (e < best) begin best = e; b_vgs = cx; b_vds = cy; end
        t = ((u_vgs - 0.21095900215479077)*(-0.0618544357438216) + (u_vds - 0.4949618775976764)*0.004579129985961605)/0.003846939652614888;
        if (t < 0.0) t = 0.0; else if (t > 1.0) t = 1.0;
        cx = 0.21095900215479077 + t*(-0.0618544357438216);
        cy = 0.4949618775976764 + t*0.004579129985961605;
        e = (u_vgs - cx)*(u_vgs - cx) + (u_vds - cy)*(u_vds - cy);
        if (e < best) begin best = e; b_vgs = cx; b_vds = cy; end
        t = ((u_vgs - 0.14910456641096917)*(-0.0677474626858589) + (u_vds - 0.499541007583638)*0.00045386318044982055)/0.0045899246921584135;
        if (t < 0.0) t = 0.0; else if (t > 1.0) t = 1.0;
        cx = 0.14910456641096917 + t*(-0.0677474626858589);
        cy = 0.499541007583638 + t*0.00045386318044982055;
        e = (u_vgs - cx)*(u_vgs - cx) + (u_vds - cy)*(u_vds - cy);
        if (e < best) begin best = e; b_vgs = cx; b_vds = cy; end
        t = ((u_vgs - 0.08135710372511026)*(-0.06838848819212097) + (u_vds - 0.49999487076408783)*5.129232941936124e-06)/0.004676985343512899;
        if (t < 0.0) t = 0.0; else if (t > 1.0) t = 1.0;
        cx = 0.08135710372511026 + t*(-0.06838848819212097);
        cy = 0.49999487076408783 + t*5.129232941936124e-06;
        e = (u_vgs - cx)*(u_vgs - cx) + (u_vds - cy)*(u_vds - cy);
        if (e < best) begin best = e; b_vgs = cx; b_vds = cy; end
        t = ((u_vgs - 0.012968615532989293)*(-0.5129686155329887) + (u_vds - 0.49999999999702976)*2.9702351689309126e-12)/0.26313680052183114;
        if (t < 0.0) t = 0.0; else if (t > 1.0) t = 1.0;
        cx = 0.012968615532989293 + t*(-0.5129686155329887);
        cy = 0.49999999999702976 + t*2.9702351689309126e-12;
        e = (u_vgs - cx)*(u_vgs - cx) + (u_vds - cy)*(u_vds - cy);
        if (e < best) begin best = e; b_vgs = cx; b_vds = cy; end
        t = ((u_vgs - (-0.4999999999999994))*(-6.106226635438361e-16) + (u_vds - 0.5)*(-3.3306690738754696e-16))/4.8379360203007365e-31;
        if (t < 0.0) t = 0.0; else if (t > 1.0) t = 1.0;
        cx = (-0.4999999999999994) + t*(-6.106226635438361e-16);
        cy = 0.5 + t*(-3.3306690738754696e-16);
        e = (u_vgs - cx)*(u_vgs - cx) + (u_vds - cy)*(u_vds - cy);
        if (e < best) begin best = e; b_vgs = cx; b_vds = cy; end
      end
      // the nearest domain point: the point itself inside, else back from normalised coordinates
      if (inside && inbox) begin
        p_vgs = vgs;
        p_vds = vds;
        p_T = T;
      end else begin
        p_vgs = (-2.075844497250043) + 5.848311005851915*b_vgs;
        p_vds = 9.999999999453182 + 19.99999999902244*b_vds;
        p_T = 75.0 + 100.0*b_T;
      end
      fb = f_IgGd(p_vgs, p_vds, p_T, g_vgs, g_vds, g_T);
      x_IgGd = fb + g_vgs*(vgs - p_vgs) + g_vds*(vds - p_vds) + g_T*(T - p_T);
      dist2 = (u_vgs - b_vgs)*(u_vgs - b_vgs) + (u_vds - b_vds)*(u_vds - b_vds) + (u_T - b_T)*(u_T - b_T);
      s = (vgs - p_vgs) - (vds - p_vds);
      // the added conductance on the constituent's own branch: ten times the edge's own, floored, capped by G_x
      ga = 10.0*(g_vgs*1.0 + g_vds*(-1.0));
      gl = min(sqrt(ga*ga + (1e-07*Gx_IgGd)*(1e-07*Gx_IgGd)), Gx_IgGd);
      if (dist2 > 0.0) x_IgGd = x_IgGd + (gl/0.05)*s*sqrt(dist2);
    end
  endfunction

  // Core.Constituents.Qg.Network (ANN, 2 hidden layers of 8 x 8, Tanh)
  analog function real f_Qg;
    input vgs, vds, T;
    output d_vgs, d_vds, d_T;
    real vgs, vds, T;
    real d_vgs, d_vds, d_T;
    real z, x1, x2, x3, h1_1, h1_1_vgs, h1_1_vds, h1_1_T, h1_2, h1_2_vgs, h1_2_vds, h1_2_T;
    real h1_3, h1_3_vgs, h1_3_vds, h1_3_T, h1_4, h1_4_vgs, h1_4_vds, h1_4_T, h1_5, h1_5_vgs, h1_5_vds, h1_5_T;
    real h1_6, h1_6_vgs, h1_6_vds, h1_6_T, h1_7, h1_7_vgs, h1_7_vds, h1_7_T, h1_8, h1_8_vgs, h1_8_vds, h1_8_T;
    real h2_1, h2_1_vgs, h2_1_vds, h2_1_T, h2_2, h2_2_vgs, h2_2_vds, h2_2_T, h2_3, h2_3_vgs, h2_3_vds, h2_3_T;
    real h2_4, h2_4_vgs, h2_4_vds, h2_4_T, h2_5, h2_5_vgs, h2_5_vds, h2_5_T, h2_6, h2_6_vgs, h2_6_vds, h2_6_T;
    real h2_7, h2_7_vgs, h2_7_vds, h2_7_T, h2_8, h2_8_vgs, h2_8_vds, h2_8_T, u, u_vgs, u_vds, u_T;
    begin
      x1 = (vgs - (-0.9208796670951123))*0.9266806794578499;
      x2 = (vds - 7.566235437630191)*0.13452134401466356;
      x3 = (T - 64.251518025185)*0.025476721673754595;
      // hidden layer 1
      z = -0.3637558756015876 + 0.3453732192212337*x1 - 0.9923288740271166*x2 - 0.001587595315250342*x3;
      h1_1 = tanh(z);
      h1_1_vgs = (1.0 - h1_1*h1_1)*(0.3200506894544778);
      h1_1_vds = (1.0 - h1_1*h1_1)*(-0.13348941383868548);
      h1_1_T = (1.0 - h1_1*h1_1)*(-4.0446723977189646e-05);
      z = -0.4523139241991508 - 0.010387229619475453*x1 + 0.24241398536256417*x2 - 0.023192819534764087*x3;
      h1_2 = tanh(z);
      h1_2_vgs = (1.0 - h1_2*h1_2)*(-0.009625645001460218);
      h1_2_vds = (1.0 - h1_2*h1_2)*(0.032609855118923115);
      h1_2_T = (1.0 - h1_2*h1_2)*(-0.0005908770081168032);
      z = 0.6442247132203237 + 0.16293509387018987*x1 - 0.5944491844924036*x2 - 0.002486632830012602*x3;
      h1_3 = tanh(z);
      h1_3_vgs = (1.0 - h1_3*h1_3)*(0.15098880349515612);
      h1_3_vds = (1.0 - h1_3*h1_3)*(-0.07996610324633883);
      h1_3_T = (1.0 - h1_3*h1_3)*(-6.335125251505178e-05);
      z = -1.3114370475934891 + 0.02692120073969437*x1 + 0.09253928310735786*x2 + 0.04006380311878135*x3;
      h1_4 = tanh(z);
      h1_4_vgs = (1.0 - h1_4*h1_4)*(0.02494735659328115);
      h1_4_vds = (1.0 - h1_4*h1_4)*(0.01244850873775523);
      h1_4_T = (1.0 - h1_4*h1_4)*(0.0010206943612492937);
      z = -1.249087070917115 + 0.16442250518824908*x1 - 1.3755190188252502*x2 + 0.0011040884110266494*x3;
      h1_5 = tanh(z);
      h1_5_vgs = (1.0 - h1_5*h1_5)*(0.15236715882600851);
      h1_5_vds = (1.0 - h1_5*h1_5)*(-0.18503666713010397);
      h1_5_T = (1.0 - h1_5*h1_5)*(2.812855315094391e-05);
      z = -0.6180488993017487 - 0.03831384840204116*x1 - 0.3528131021219113*x2 + 0.0014055580820843457*x3;
      h1_6 = tanh(z);
      h1_6_vgs = (1.0 - h1_6*h1_6)*(-0.03550470306984856);
      h1_6_vds = (1.0 - h1_6*h1_6)*(-0.04746089268342226);
      h1_6_T = (1.0 - h1_6*h1_6)*(3.580901205355919e-05);
      z = 1.1626534001066242 + 0.4629830883804438*x1 + 0.432175265200138*x2 - 0.0008484417497798104*x3;
      h1_7 = tanh(z);
      h1_7_vgs = (1.0 - h1_7*h1_7)*(0.4290374829178834);
      h1_7_vds = (1.0 - h1_7*h1_7)*(0.05813679752461622);
      h1_7_T = (1.0 - h1_7*h1_7)*(-2.1615514315533568e-05);
      z = -0.29015865381605854 + 0.14021259943517947*x1 + 0.21170398755128278*x2 - 0.004747408866676142*x3;
      h1_8 = tanh(z);
      h1_8_vgs = (1.0 - h1_8*h1_8)*(0.12993230691314345);
      h1_8_vds = (1.0 - h1_8*h1_8)*(0.028478704938662162);
      h1_8_T = (1.0 - h1_8*h1_8)*(-0.0001209484143678228);
      // hidden layer 2
      z = 0.4709736280025499 + 0.11962256917211803*h1_1 - 0.09445857733360931*h1_2 + 0.0321853101971133*h1_3 - 0.25704741640122697*h1_4 - 0.41259658642532976*h1_5 + 0.9373006104497028*h1_6 - 0.23570816114715426*h1_7 - 0.24605094393764962*h1_8;
      h2_1 = tanh(z);
      h2_1_vgs = (1.0 - h2_1*h2_1)*(0.11962256917211803*h1_1_vgs - 0.09445857733360931*h1_2_vgs + 0.0321853101971133*h1_3_vgs - 0.25704741640122697*h1_4_vgs - 0.41259658642532976*h1_5_vgs + 0.9373006104497028*h1_6_vgs - 0.23570816114715426*h1_7_vgs - 0.24605094393764962*h1_8_vgs);
      h2_1_vds = (1.0 - h2_1*h2_1)*(0.11962256917211803*h1_1_vds - 0.09445857733360931*h1_2_vds + 0.0321853101971133*h1_3_vds - 0.25704741640122697*h1_4_vds - 0.41259658642532976*h1_5_vds + 0.9373006104497028*h1_6_vds - 0.23570816114715426*h1_7_vds - 0.24605094393764962*h1_8_vds);
      h2_1_T = (1.0 - h2_1*h2_1)*(0.11962256917211803*h1_1_T - 0.09445857733360931*h1_2_T + 0.0321853101971133*h1_3_T - 0.25704741640122697*h1_4_T - 0.41259658642532976*h1_5_T + 0.9373006104497028*h1_6_T - 0.23570816114715426*h1_7_T - 0.24605094393764962*h1_8_T);
      z = 0.4457696589319789 + 0.46751504547811285*h1_1 - 0.5305340982149718*h1_2 + 0.9552119799861979*h1_3 - 0.4228561515691911*h1_4 + 0.04898101823307815*h1_5 - 0.3698843441076933*h1_6 + 0.20117935381441887*h1_7 + 0.2882850152581487*h1_8;
      h2_2 = tanh(z);
      h2_2_vgs = (1.0 - h2_2*h2_2)*(0.46751504547811285*h1_1_vgs - 0.5305340982149718*h1_2_vgs + 0.9552119799861979*h1_3_vgs - 0.4228561515691911*h1_4_vgs + 0.04898101823307815*h1_5_vgs - 0.3698843441076933*h1_6_vgs + 0.20117935381441887*h1_7_vgs + 0.2882850152581487*h1_8_vgs);
      h2_2_vds = (1.0 - h2_2*h2_2)*(0.46751504547811285*h1_1_vds - 0.5305340982149718*h1_2_vds + 0.9552119799861979*h1_3_vds - 0.4228561515691911*h1_4_vds + 0.04898101823307815*h1_5_vds - 0.3698843441076933*h1_6_vds + 0.20117935381441887*h1_7_vds + 0.2882850152581487*h1_8_vds);
      h2_2_T = (1.0 - h2_2*h2_2)*(0.46751504547811285*h1_1_T - 0.5305340982149718*h1_2_T + 0.9552119799861979*h1_3_T - 0.4228561515691911*h1_4_T + 0.04898101823307815*h1_5_T - 0.3698843441076933*h1_6_T + 0.20117935381441887*h1_7_T + 0.2882850152581487*h1_8_T);
      z = -0.05889011962713903 + 0.04069818361783333*h1_1 + 0.035732027825172444*h1_2 - 0.2958719774084451*h1_3 - 0.2833113221669226*h1_4 - 0.1967053371879806*h1_5 - 0.20507874292595768*h1_6 - 0.27272084603876934*h1_7 - 0.5719528065403512*h1_8;
      h2_3 = tanh(z);
      h2_3_vgs = (1.0 - h2_3*h2_3)*(0.04069818361783333*h1_1_vgs + 0.035732027825172444*h1_2_vgs - 0.2958719774084451*h1_3_vgs - 0.2833113221669226*h1_4_vgs - 0.1967053371879806*h1_5_vgs - 0.20507874292595768*h1_6_vgs - 0.27272084603876934*h1_7_vgs - 0.5719528065403512*h1_8_vgs);
      h2_3_vds = (1.0 - h2_3*h2_3)*(0.04069818361783333*h1_1_vds + 0.035732027825172444*h1_2_vds - 0.2958719774084451*h1_3_vds - 0.2833113221669226*h1_4_vds - 0.1967053371879806*h1_5_vds - 0.20507874292595768*h1_6_vds - 0.27272084603876934*h1_7_vds - 0.5719528065403512*h1_8_vds);
      h2_3_T = (1.0 - h2_3*h2_3)*(0.04069818361783333*h1_1_T + 0.035732027825172444*h1_2_T - 0.2958719774084451*h1_3_T - 0.2833113221669226*h1_4_T - 0.1967053371879806*h1_5_T - 0.20507874292595768*h1_6_T - 0.27272084603876934*h1_7_T - 0.5719528065403512*h1_8_T);
      z = -0.594891706772195 + 0.7422370021686616*h1_1 + 0.26735252942272925*h1_2 - 0.04101194110968366*h1_3 + 0.4022235253705055*h1_4 + 0.14130062698376772*h1_5 - 1.2806976967038375*h1_6 + 0.020282818097082593*h1_7 + 0.7405443249406135*h1_8;
      h2_4 = tanh(z);
      h2_4_vgs = (1.0 - h2_4*h2_4)*(0.7422370021686616*h1_1_vgs + 0.26735252942272925*h1_2_vgs - 0.04101194110968366*h1_3_vgs + 0.4022235253705055*h1_4_vgs + 0.14130062698376772*h1_5_vgs - 1.2806976967038375*h1_6_vgs + 0.020282818097082593*h1_7_vgs + 0.7405443249406135*h1_8_vgs);
      h2_4_vds = (1.0 - h2_4*h2_4)*(0.7422370021686616*h1_1_vds + 0.26735252942272925*h1_2_vds - 0.04101194110968366*h1_3_vds + 0.4022235253705055*h1_4_vds + 0.14130062698376772*h1_5_vds - 1.2806976967038375*h1_6_vds + 0.020282818097082593*h1_7_vds + 0.7405443249406135*h1_8_vds);
      h2_4_T = (1.0 - h2_4*h2_4)*(0.7422370021686616*h1_1_T + 0.26735252942272925*h1_2_T - 0.04101194110968366*h1_3_T + 0.4022235253705055*h1_4_T + 0.14130062698376772*h1_5_T - 1.2806976967038375*h1_6_T + 0.020282818097082593*h1_7_T + 0.7405443249406135*h1_8_T);
      z = 0.017413852666497167 + 0.36478592458952636*h1_1 - 0.30493639886403545*h1_2 + 0.09936984043464762*h1_3 + 0.1929697996366971*h1_4 + 0.514433986828323*h1_5 - 0.29957874466843804*h1_6 - 0.563379458266838*h1_7 - 0.36759545438246277*h1_8;
      h2_5 = tanh(z);
      h2_5_vgs = (1.0 - h2_5*h2_5)*(0.36478592458952636*h1_1_vgs - 0.30493639886403545*h1_2_vgs + 0.09936984043464762*h1_3_vgs + 0.1929697996366971*h1_4_vgs + 0.514433986828323*h1_5_vgs - 0.29957874466843804*h1_6_vgs - 0.563379458266838*h1_7_vgs - 0.36759545438246277*h1_8_vgs);
      h2_5_vds = (1.0 - h2_5*h2_5)*(0.36478592458952636*h1_1_vds - 0.30493639886403545*h1_2_vds + 0.09936984043464762*h1_3_vds + 0.1929697996366971*h1_4_vds + 0.514433986828323*h1_5_vds - 0.29957874466843804*h1_6_vds - 0.563379458266838*h1_7_vds - 0.36759545438246277*h1_8_vds);
      h2_5_T = (1.0 - h2_5*h2_5)*(0.36478592458952636*h1_1_T - 0.30493639886403545*h1_2_T + 0.09936984043464762*h1_3_T + 0.1929697996366971*h1_4_T + 0.514433986828323*h1_5_T - 0.29957874466843804*h1_6_T - 0.563379458266838*h1_7_T - 0.36759545438246277*h1_8_T);
      z = 0.09587755103398453 - 0.8234570989892074*h1_1 - 0.10059569848973306*h1_2 - 0.7856442965983007*h1_3 - 0.3651345164063168*h1_4 + 0.9242554167158669*h1_5 + 0.6989364419589107*h1_6 - 0.036829021081949596*h1_7 - 0.40951951354784777*h1_8;
      h2_6 = tanh(z);
      h2_6_vgs = (1.0 - h2_6*h2_6)*(- 0.8234570989892074*h1_1_vgs - 0.10059569848973306*h1_2_vgs - 0.7856442965983007*h1_3_vgs - 0.3651345164063168*h1_4_vgs + 0.9242554167158669*h1_5_vgs + 0.6989364419589107*h1_6_vgs - 0.036829021081949596*h1_7_vgs - 0.40951951354784777*h1_8_vgs);
      h2_6_vds = (1.0 - h2_6*h2_6)*(- 0.8234570989892074*h1_1_vds - 0.10059569848973306*h1_2_vds - 0.7856442965983007*h1_3_vds - 0.3651345164063168*h1_4_vds + 0.9242554167158669*h1_5_vds + 0.6989364419589107*h1_6_vds - 0.036829021081949596*h1_7_vds - 0.40951951354784777*h1_8_vds);
      h2_6_T = (1.0 - h2_6*h2_6)*(- 0.8234570989892074*h1_1_T - 0.10059569848973306*h1_2_T - 0.7856442965983007*h1_3_T - 0.3651345164063168*h1_4_T + 0.9242554167158669*h1_5_T + 0.6989364419589107*h1_6_T - 0.036829021081949596*h1_7_T - 0.40951951354784777*h1_8_T);
      z = -0.356404172492422 + 0.2146109794252869*h1_1 - 0.4829145157960442*h1_2 + 0.2779668478443868*h1_3 + 0.20656913577844724*h1_4 + 0.021875820921017263*h1_5 - 0.29023407923815053*h1_6 + 0.07311233325515872*h1_7 + 0.8318863866878794*h1_8;
      h2_7 = tanh(z);
      h2_7_vgs = (1.0 - h2_7*h2_7)*(0.2146109794252869*h1_1_vgs - 0.4829145157960442*h1_2_vgs + 0.2779668478443868*h1_3_vgs + 0.20656913577844724*h1_4_vgs + 0.021875820921017263*h1_5_vgs - 0.29023407923815053*h1_6_vgs + 0.07311233325515872*h1_7_vgs + 0.8318863866878794*h1_8_vgs);
      h2_7_vds = (1.0 - h2_7*h2_7)*(0.2146109794252869*h1_1_vds - 0.4829145157960442*h1_2_vds + 0.2779668478443868*h1_3_vds + 0.20656913577844724*h1_4_vds + 0.021875820921017263*h1_5_vds - 0.29023407923815053*h1_6_vds + 0.07311233325515872*h1_7_vds + 0.8318863866878794*h1_8_vds);
      h2_7_T = (1.0 - h2_7*h2_7)*(0.2146109794252869*h1_1_T - 0.4829145157960442*h1_2_T + 0.2779668478443868*h1_3_T + 0.20656913577844724*h1_4_T + 0.021875820921017263*h1_5_T - 0.29023407923815053*h1_6_T + 0.07311233325515872*h1_7_T + 0.8318863866878794*h1_8_T);
      z = -0.7754826696121152 + 1.2546480013638108*h1_1 - 0.4093932291001875*h1_2 + 0.3646865796231494*h1_3 - 0.05986029451092251*h1_4 + 0.9105778579502084*h1_5 + 0.6082148769376191*h1_6 - 1.4330491895740476*h1_7 + 1.0060032818474456*h1_8;
      h2_8 = tanh(z);
      h2_8_vgs = (1.0 - h2_8*h2_8)*(1.2546480013638108*h1_1_vgs - 0.4093932291001875*h1_2_vgs + 0.3646865796231494*h1_3_vgs - 0.05986029451092251*h1_4_vgs + 0.9105778579502084*h1_5_vgs + 0.6082148769376191*h1_6_vgs - 1.4330491895740476*h1_7_vgs + 1.0060032818474456*h1_8_vgs);
      h2_8_vds = (1.0 - h2_8*h2_8)*(1.2546480013638108*h1_1_vds - 0.4093932291001875*h1_2_vds + 0.3646865796231494*h1_3_vds - 0.05986029451092251*h1_4_vds + 0.9105778579502084*h1_5_vds + 0.6082148769376191*h1_6_vds - 1.4330491895740476*h1_7_vds + 1.0060032818474456*h1_8_vds);
      h2_8_T = (1.0 - h2_8*h2_8)*(1.2546480013638108*h1_1_T - 0.4093932291001875*h1_2_T + 0.3646865796231494*h1_3_T - 0.05986029451092251*h1_4_T + 0.9105778579502084*h1_5_T + 0.6082148769376191*h1_6_T - 1.4330491895740476*h1_7_T + 1.0060032818474456*h1_8_T);
      // output
      u = -1.3623426036804986 - 0.8479847226899015*h2_1 + 1.6004655041728928*h2_2 - 0.1921282259735084*h2_3 + 1.3521581218362921*h2_4 + 0.6704270182426382*h2_5 - 1.9742163674543047*h2_6 + 0.9231977751685685*h2_7 + 1.2968005030335896*h2_8;
      u_vgs = - 0.8479847226899015*h2_1_vgs + 1.6004655041728928*h2_2_vgs - 0.1921282259735084*h2_3_vgs + 1.3521581218362921*h2_4_vgs + 0.6704270182426382*h2_5_vgs - 1.9742163674543047*h2_6_vgs + 0.9231977751685685*h2_7_vgs + 1.2968005030335896*h2_8_vgs;
      u_vds = - 0.8479847226899015*h2_1_vds + 1.6004655041728928*h2_2_vds - 0.1921282259735084*h2_3_vds + 1.3521581218362921*h2_4_vds + 0.6704270182426382*h2_5_vds - 1.9742163674543047*h2_6_vds + 0.9231977751685685*h2_7_vds + 1.2968005030335896*h2_8_vds;
      u_T = - 0.8479847226899015*h2_1_T + 1.6004655041728928*h2_2_T - 0.1921282259735084*h2_3_T + 1.3521581218362921*h2_4_T + 0.6704270182426382*h2_5_T - 1.9742163674543047*h2_6_T + 0.9231977751685685*h2_7_T + 1.2968005030335896*h2_8_T;
      f_Qg = 0.0 + 4.0013788575836924e-13*u;
      d_vgs = 4.0013788575836924e-13*u_vgs;
      d_vds = 4.0013788575836924e-13*u_vds;
      d_T = 4.0013788575836924e-13*u_T;
    end
  endfunction

  // Core.Constituents.Qg.Network continued outside Core.Constituents.Qg.Domain (guided extrapolation)
  analog function real x_Qg;
    input vgs, vds, T;
    real vgs, vds, T;
    real u_vgs, u_vds, u_T, b_vgs, b_vds, b_T, p_vgs, p_vds, p_T, g_vgs, g_vds, g_T;
    real t, cx, cy, e, best, cr, fb, s, dist2, gl, ga;
    integer inside, inbox;
    begin
      // normalised by the domain's centre and extent
      u_vgs = (vgs - (-0.9208796670951123))/2.1582407449889756;
      u_vds = (vds - 7.566235437630191)/14.867529124463616;
      u_T = (T - 64.251518025185)/78.50303605037001;
      inbox = 1;
      // Domain.Box.T
      if (u_T < (-0.5)) begin b_T = (-0.5); inbox = 0; end
      else if (u_T > 0.5) begin b_T = 0.5; inbox = 0; end
      else b_T = u_T;
      // Domain.Polygon: 10 vertices, counter-clockwise
      inside = 1;
      cr = 0.9945485555180813*(u_vds - (-0.47527975047364995)) - (-0.024720249526350158)*(u_vgs - (-0.5));
      if (cr < 0.0) inside = 0;
      cr = 0.005451444481918644*(u_vds - (-0.5000000000000001)) - 0.0018944617201674951*(u_vgs - 0.49454855551808136);
      if (cr < 0.0) inside = 0;
      cr = (-0.09398705129148938)*(u_vds - (-0.4981055382798326)) - 0.9426177824000829*(u_vgs - 0.5);
      if (cr < 0.0) inside = 0;
      cr = (-0.09249964651191961)*(u_vds - 0.44451224412025026) - 0.016160326304840433*(u_vgs - 0.4060129487085106);
      if (cr < 0.0) inside = 0;
      cr = (-0.13091432540818732)*(u_vds - 0.4606725704250907) - 0.01891242532930726*(u_vgs - 0.313513302196591);
      if (cr < 0.0) inside = 0;
      cr = (-0.14509413109986158)*(u_vds - 0.47958499575439795) - 0.013984722374358438*(u_vgs - 0.1825989767884037);
      if (cr < 0.0) inside = 0;
      cr = (-0.16824602428679386)*(u_vds - 0.4935697181287564) - 0.005939079510797307*(u_vgs - 0.037504845688542135);
      if (cr < 0.0) inside = 0;
      cr = (-0.18393634886175214)*(u_vds - 0.4995087976395537) - 0.00048644775735068313*(u_vgs - (-0.13074117859825174));
      if (cr < 0.0) inside = 0;
      cr = (-0.1853224541917186)*(u_vds - 0.4999952453969044) - 4.754603095624699e-06*(u_vgs - (-0.3146775274600039));
      if (cr < 0.0) inside = 0;
      cr = (-1.834827750846202e-08)*(u_vds - 0.5) - (-0.9752797504736499)*(u_vgs - (-0.4999999816517225));
      if (cr < 0.0) inside = 0;
      if (inside) begin
        b_vgs = u_vgs;
        b_vds = u_vds;
      end else begin
        t = ((u_vgs - (-0.5))*0.9945485555180813 + (u_vds - (-0.47527975047364995))*(-0.024720249526350158))/0.989737920019747;
        if (t < 0.0) t = 0.0; else if (t > 1.0) t = 1.0;
        cx = (-0.5) + t*0.9945485555180813;
        cy = (-0.47527975047364995) + t*(-0.024720249526350158);
        e = (u_vgs - cx)*(u_vgs - cx) + (u_vds - cy)*(u_vds - cy);
        best = e; b_vgs = cx; b_vds = cy;
        t = ((u_vgs - 0.49454855551808136)*0.005451444481918644 + (u_vds - (-0.5000000000000001))*0.0018944617201674951)/3.3307232148621213e-05;
        if (t < 0.0) t = 0.0; else if (t > 1.0) t = 1.0;
        cx = 0.49454855551808136 + t*0.005451444481918644;
        cy = (-0.5000000000000001) + t*0.0018944617201674951;
        e = (u_vgs - cx)*(u_vgs - cx) + (u_vds - cy)*(u_vds - cy);
        if (e < best) begin best = e; b_vgs = cx; b_vds = cy; end
        t = ((u_vgs - 0.5)*(-0.09398705129148938) + (u_vds - (-0.4981055382798326))*0.9426177824000829)/0.897361849507319;
        if (t < 0.0) t = 0.0; else if (t > 1.0) t = 1.0;
        cx = 0.5 + t*(-0.09398705129148938);
        cy = (-0.4981055382798326) + t*0.9426177824000829;
        e = (u_vgs - cx)*(u_vgs - cx) + (u_vds - cy)*(u_vds - cy);
        if (e < best) begin best = e; b_vgs = cx; b_vds = cy; end
        t = ((u_vgs - 0.4060129487085106)*(-0.09249964651191961) + (u_vds - 0.44451224412025026)*0.016160326304840433)/0.008817340751109;
        if (t < 0.0) t = 0.0; else if (t > 1.0) t = 1.0;
        cx = 0.4060129487085106 + t*(-0.09249964651191961);
        cy = 0.44451224412025026 + t*0.016160326304840433;
        e = (u_vgs - cx)*(u_vgs - cx) + (u_vds - cy)*(u_vds - cy);
        if (e < best) begin best = e; b_vgs = cx; b_vds = cy; end
        t = ((u_vgs - 0.313513302196591)*(-0.13091432540818732) + (u_vds - 0.4606725704250907)*0.01891242532930726)/0.017496240428917384;
        if (t < 0.0) t = 0.0; else if (t > 1.0) t = 1.0;
        cx = 0.313513302196591 + t*(-0.13091432540818732);
        cy = 0.4606725704250907 + t*0.01891242532930726;
        e = (u_vgs - cx)*(u_vgs - cx) + (u_vds - cy)*(u_vds - cy);
        if (e < best) begin best = e; b_vgs = cx; b_vds = cy; end
        t = ((u_vgs - 0.1825989767884037)*(-0.14509413109986158) + (u_vds - 0.47958499575439795)*0.013984722374358438)/0.0212478793395117;
        if (t < 0.0) t = 0.0; else if (t > 1.0) t = 1.0;
        cx = 0.1825989767884037 + t*(-0.14509413109986158);
        cy = 0.47958499575439795 + t*0.013984722374358438;
        e = (u_vgs - cx)*(u_vgs - cx) + (u_vds - cy)*(u_vds - cy);
        if (e < best) begin best = e; b_vgs = cx; b_vds = cy; end
        t = ((u_vgs - 0.037504845688542135)*(-0.16824602428679386) + (u_vds - 0.4935697181287564)*0.005939079510797307)/0.028341997353748004;
        if (t < 0.0) t = 0.0; else if (t > 1.0) t = 1.0;
        cx = 0.037504845688542135 + t*(-0.16824602428679386);
        cy = 0.4935697181287564 + t*0.005939079510797307;
        e = (u_vgs - cx)*(u_vgs - cx) + (u_vds - cy)*(u_vds - cy);
        if (e < best) begin best = e; b_vgs = cx; b_vds = cy; end
        t = ((u_vgs - (-0.13074117859825174))*(-0.18393634886175214) + (u_vds - 0.4995087976395537)*0.00048644775735068313)/0.03383281706401282;
        if (t < 0.0) t = 0.0; else if (t > 1.0) t = 1.0;
        cx = (-0.13074117859825174) + t*(-0.18393634886175214);
        cy = 0.4995087976395537 + t*0.00048644775735068313;
        e = (u_vgs - cx)*(u_vgs - cx) + (u_vds - cy)*(u_vds - cy);
        if (e < best) begin best = e; b_vgs = cx; b_vds = cy; end
        t = ((u_vgs - (-0.3146775274600039))*(-0.1853224541917186) + (u_vds - 0.4999952453969044)*4.754603095624699e-06)/0.034344412050247894;
        if (t < 0.0) t = 0.0; else if (t > 1.0) t = 1.0;
        cx = (-0.3146775274600039) + t*(-0.1853224541917186);
        cy = 0.4999952453969044 + t*4.754603095624699e-06;
        e = (u_vgs - cx)*(u_vgs - cx) + (u_vds - cy)*(u_vds - cy);
        if (e < best) begin best = e; b_vgs = cx; b_vds = cy; end
        t = ((u_vgs - (-0.4999999816517225))*(-1.834827750846202e-08) + (u_vds - 0.5)*(-0.9752797504736499))/0.9511705916839451;
        if (t < 0.0) t = 0.0; else if (t > 1.0) t = 1.0;
        cx = (-0.4999999816517225) + t*(-1.834827750846202e-08);
        cy = 0.5 + t*(-0.9752797504736499);
        e = (u_vgs - cx)*(u_vgs - cx) + (u_vds - cy)*(u_vds - cy);
        if (e < best) begin best = e; b_vgs = cx; b_vds = cy; end
      end
      // the nearest domain point: the point itself inside, else back from normalised coordinates
      if (inside && inbox) begin
        p_vgs = vgs;
        p_vds = vds;
        p_T = T;
      end else begin
        p_vgs = (-0.9208796670951123) + 2.1582407449889756*b_vgs;
        p_vds = 7.566235437630191 + 14.867529124463616*b_vds;
        p_T = 64.251518025185 + 78.50303605037001*b_T;
      end
      fb = f_Qg(p_vgs, p_vds, p_T, g_vgs, g_vds, g_T);
      x_Qg = fb + g_vgs*(vgs - p_vgs) + g_vds*(vds - p_vds) + g_T*(T - p_T);
    end
  endfunction

  // Core.Constituents.Qd.Network (ANN, 2 hidden layers of 8 x 8, Tanh)
  analog function real f_Qd;
    input vgs, vds, T;
    output d_vgs, d_vds, d_T;
    real vgs, vds, T;
    real d_vgs, d_vds, d_T;
    real z, x1, x2, x3, h1_1, h1_1_vgs, h1_1_vds, h1_1_T, h1_2, h1_2_vgs, h1_2_vds, h1_2_T;
    real h1_3, h1_3_vgs, h1_3_vds, h1_3_T, h1_4, h1_4_vgs, h1_4_vds, h1_4_T, h1_5, h1_5_vgs, h1_5_vds, h1_5_T;
    real h1_6, h1_6_vgs, h1_6_vds, h1_6_T, h1_7, h1_7_vgs, h1_7_vds, h1_7_T, h1_8, h1_8_vgs, h1_8_vds, h1_8_T;
    real h2_1, h2_1_vgs, h2_1_vds, h2_1_T, h2_2, h2_2_vgs, h2_2_vds, h2_2_T, h2_3, h2_3_vgs, h2_3_vds, h2_3_T;
    real h2_4, h2_4_vgs, h2_4_vds, h2_4_T, h2_5, h2_5_vgs, h2_5_vds, h2_5_T, h2_6, h2_6_vgs, h2_6_vds, h2_6_T;
    real h2_7, h2_7_vgs, h2_7_vds, h2_7_T, h2_8, h2_8_vgs, h2_8_vds, h2_8_T, u, u_vgs, u_vds, u_T;
    begin
      x1 = (vgs - (-0.9208796670951123))*0.9266806794578499;
      x2 = (vds - 7.566235437630191)*0.13452134401466356;
      x3 = (T - 64.251518025185)*0.025476721673754595;
      // hidden layer 1
      z = -0.4409039123793923 - 0.011381735093289005*x1 + 0.6368703371649228*x2 + 0.0037664386438230153*x3;
      h1_1 = tanh(z);
      h1_1_vgs = (1.0 - h1_1*h1_1)*(-0.01054723400965831);
      h1_1_vds = (1.0 - h1_1*h1_1)*(0.08567265371849736);
      h1_1_T = (1.0 - h1_1*h1_1)*(9.595650902995267e-05);
      z = 2.45825413115937 + 0.018837219766566105*x1 + 2.4980173852902707*x2 - 0.014898284596705426*x3;
      h1_2 = tanh(z);
      h1_2_vgs = (1.0 - h1_2*h1_2)*(0.01745608761237832);
      h1_2_vds = (1.0 - h1_2*h1_2)*(0.3360366560412429);
      h1_2_T = (1.0 - h1_2*h1_2)*(-0.00037955945008664934);
      z = -0.0391861826632896 + 0.009358366494330137*x1 - 0.11764553360375875*x2 - 0.08788085156397929*x3;
      h1_3 = tanh(z);
      h1_3_vgs = (1.0 - h1_3*h1_3)*(0.008672217421581429);
      h1_3_vds = (1.0 - h1_3*h1_3)*(-0.015825835297699892);
      h1_3_T = (1.0 - h1_3*h1_3)*(-0.0022389159957480415);
      z = 0.586398055324918 - 0.0123009168204501*x1 + 0.6833252082934453*x2 - 0.037651615823980855*x3;
      h1_4 = tanh(z);
      h1_4_vgs = (1.0 - h1_4*h1_4)*(-0.011399021957129194);
      h1_4_vds = (1.0 - h1_4*h1_4)*(0.0919218254187342);
      h1_4_T = (1.0 - h1_4*h1_4)*(-0.0009592397369146945);
      z = 0.46986978195048584 - 0.03315303952346632*x1 + 0.5339778745104701*x2 + 0.11866430743094514*x3;
      h1_5 = tanh(z);
      h1_5_vgs = (1.0 - h1_5*h1_5)*(-0.030722281191698723);
      h1_5_vds = (1.0 - h1_5*h1_5)*(0.07183142135324179);
      h1_5_T = (1.0 - h1_5*h1_5)*(0.0030231775330270385);
      z = 1.0500540649041596 - 0.024413259463041913*x1 - 0.18558672527173922*x2 + 0.0598309694858573*x3;
      h1_6 = tanh(z);
      h1_6_vgs = (1.0 - h1_6*h1_6)*(-0.022623295866992466);
      h1_6_vds = (1.0 - h1_6*h1_6)*(-0.024965375714834488);
      h1_6_T = (1.0 - h1_6*h1_6)*(0.0015242969570620905);
      z = -2.1611430808380647 + 0.05572018825698978*x1 - 1.2062194707756406*x2 + 0.0009517227456368826*x3;
      h1_7 = tanh(z);
      h1_7_vgs = (1.0 - h1_7*h1_7)*(0.0516348219135066);
      h1_7_vds = (1.0 - h1_7*h1_7)*(-0.16226226438539537);
      h1_7_T = (1.0 - h1_7*h1_7)*(2.4246775501172398e-05);
      z = 0.5265128012773911 + 0.0004133483455408087*x1 + 0.36145996966153005*x2 - 0.0038253004541466237*x3;
      h1_8 = tanh(z);
      h1_8_vgs = (1.0 - h1_8*h1_8)*(0.00038304192569853473);
      h1_8_vds = (1.0 - h1_8*h1_8)*(0.04862408092636854);
      h1_8_T = (1.0 - h1_8*h1_8)*(-9.745611498878058e-05);
      // hidden layer 2
      z = 0.15155581445562585 + 0.3551435597808497*h1_1 + 0.4210214174303734*h1_2 + 0.04936187585299919*h1_3 + 0.2730608083120263*h1_4 - 0.26471984308178365*h1_5 + 0.6463115447967194*h1_6 + 0.09466816045982983*h1_7 + 0.07383277218182761*h1_8;
      h2_1 = tanh(z);
      h2_1_vgs = (1.0 - h2_1*h2_1)*(0.3551435597808497*h1_1_vgs + 0.4210214174303734*h1_2_vgs + 0.04936187585299919*h1_3_vgs + 0.2730608083120263*h1_4_vgs - 0.26471984308178365*h1_5_vgs + 0.6463115447967194*h1_6_vgs + 0.09466816045982983*h1_7_vgs + 0.07383277218182761*h1_8_vgs);
      h2_1_vds = (1.0 - h2_1*h2_1)*(0.3551435597808497*h1_1_vds + 0.4210214174303734*h1_2_vds + 0.04936187585299919*h1_3_vds + 0.2730608083120263*h1_4_vds - 0.26471984308178365*h1_5_vds + 0.6463115447967194*h1_6_vds + 0.09466816045982983*h1_7_vds + 0.07383277218182761*h1_8_vds);
      h2_1_T = (1.0 - h2_1*h2_1)*(0.3551435597808497*h1_1_T + 0.4210214174303734*h1_2_T + 0.04936187585299919*h1_3_T + 0.2730608083120263*h1_4_T - 0.26471984308178365*h1_5_T + 0.6463115447967194*h1_6_T + 0.09466816045982983*h1_7_T + 0.07383277218182761*h1_8_T);
      z = 0.43322649023084475 + 0.20449267801717255*h1_1 - 0.8062926109844439*h1_2 + 0.18908138177085065*h1_3 - 0.7237719115158205*h1_4 - 0.40982017743037247*h1_5 + 0.05401972836878898*h1_6 + 0.4030212223059671*h1_7 - 0.45539985459518856*h1_8;
      h2_2 = tanh(z);
      h2_2_vgs = (1.0 - h2_2*h2_2)*(0.20449267801717255*h1_1_vgs - 0.8062926109844439*h1_2_vgs + 0.18908138177085065*h1_3_vgs - 0.7237719115158205*h1_4_vgs - 0.40982017743037247*h1_5_vgs + 0.05401972836878898*h1_6_vgs + 0.4030212223059671*h1_7_vgs - 0.45539985459518856*h1_8_vgs);
      h2_2_vds = (1.0 - h2_2*h2_2)*(0.20449267801717255*h1_1_vds - 0.8062926109844439*h1_2_vds + 0.18908138177085065*h1_3_vds - 0.7237719115158205*h1_4_vds - 0.40982017743037247*h1_5_vds + 0.05401972836878898*h1_6_vds + 0.4030212223059671*h1_7_vds - 0.45539985459518856*h1_8_vds);
      h2_2_T = (1.0 - h2_2*h2_2)*(0.20449267801717255*h1_1_T - 0.8062926109844439*h1_2_T + 0.18908138177085065*h1_3_T - 0.7237719115158205*h1_4_T - 0.40982017743037247*h1_5_T + 0.05401972836878898*h1_6_T + 0.4030212223059671*h1_7_T - 0.45539985459518856*h1_8_T);
      z = 0.02444827051358861 - 0.10998629642425015*h1_1 - 0.16139150163969151*h1_2 - 0.34862033800707254*h1_3 - 0.4969577152816076*h1_4 - 0.29426109358321484*h1_5 - 0.10314400022418588*h1_6 - 0.2167842885832443*h1_7 - 0.6957712289171193*h1_8;
      h2_3 = tanh(z);
      h2_3_vgs = (1.0 - h2_3*h2_3)*(- 0.10998629642425015*h1_1_vgs - 0.16139150163969151*h1_2_vgs - 0.34862033800707254*h1_3_vgs - 0.4969577152816076*h1_4_vgs - 0.29426109358321484*h1_5_vgs - 0.10314400022418588*h1_6_vgs - 0.2167842885832443*h1_7_vgs - 0.6957712289171193*h1_8_vgs);
      h2_3_vds = (1.0 - h2_3*h2_3)*(- 0.10998629642425015*h1_1_vds - 0.16139150163969151*h1_2_vds - 0.34862033800707254*h1_3_vds - 0.4969577152816076*h1_4_vds - 0.29426109358321484*h1_5_vds - 0.10314400022418588*h1_6_vds - 0.2167842885832443*h1_7_vds - 0.6957712289171193*h1_8_vds);
      h2_3_T = (1.0 - h2_3*h2_3)*(- 0.10998629642425015*h1_1_T - 0.16139150163969151*h1_2_T - 0.34862033800707254*h1_3_T - 0.4969577152816076*h1_4_T - 0.29426109358321484*h1_5_T - 0.10314400022418588*h1_6_T - 0.2167842885832443*h1_7_T - 0.6957712289171193*h1_8_T);
      z = 0.42223377015104085 + 0.31587620448934833*h1_1 + 0.652334968582689*h1_2 - 0.011015941304574443*h1_3 - 0.5749935909331874*h1_4 + 0.18477326374126474*h1_5 - 0.2156145060046444*h1_6 - 0.5397755313903257*h1_7 + 1.0429463084973176*h1_8;
      h2_4 = tanh(z);
      h2_4_vgs = (1.0 - h2_4*h2_4)*(0.31587620448934833*h1_1_vgs + 0.652334968582689*h1_2_vgs - 0.011015941304574443*h1_3_vgs - 0.5749935909331874*h1_4_vgs + 0.18477326374126474*h1_5_vgs - 0.2156145060046444*h1_6_vgs - 0.5397755313903257*h1_7_vgs + 1.0429463084973176*h1_8_vgs);
      h2_4_vds = (1.0 - h2_4*h2_4)*(0.31587620448934833*h1_1_vds + 0.652334968582689*h1_2_vds - 0.011015941304574443*h1_3_vds - 0.5749935909331874*h1_4_vds + 0.18477326374126474*h1_5_vds - 0.2156145060046444*h1_6_vds - 0.5397755313903257*h1_7_vds + 1.0429463084973176*h1_8_vds);
      h2_4_T = (1.0 - h2_4*h2_4)*(0.31587620448934833*h1_1_T + 0.652334968582689*h1_2_T - 0.011015941304574443*h1_3_T - 0.5749935909331874*h1_4_T + 0.18477326374126474*h1_5_T - 0.2156145060046444*h1_6_T - 0.5397755313903257*h1_7_T + 1.0429463084973176*h1_8_T);
      z = -0.03826574324386326 - 0.12637967796106395*h1_1 - 1.6584965339860827*h1_2 - 0.21675062922717997*h1_3 + 0.39340038585118614*h1_4 + 0.8906320947123818*h1_5 - 0.23988539949985616*h1_6 + 0.547954966610345*h1_7 - 1.0611851455917574*h1_8;
      h2_5 = tanh(z);
      h2_5_vgs = (1.0 - h2_5*h2_5)*(- 0.12637967796106395*h1_1_vgs - 1.6584965339860827*h1_2_vgs - 0.21675062922717997*h1_3_vgs + 0.39340038585118614*h1_4_vgs + 0.8906320947123818*h1_5_vgs - 0.23988539949985616*h1_6_vgs + 0.547954966610345*h1_7_vgs - 1.0611851455917574*h1_8_vgs);
      h2_5_vds = (1.0 - h2_5*h2_5)*(- 0.12637967796106395*h1_1_vds - 1.6584965339860827*h1_2_vds - 0.21675062922717997*h1_3_vds + 0.39340038585118614*h1_4_vds + 0.8906320947123818*h1_5_vds - 0.23988539949985616*h1_6_vds + 0.547954966610345*h1_7_vds - 1.0611851455917574*h1_8_vds);
      h2_5_T = (1.0 - h2_5*h2_5)*(- 0.12637967796106395*h1_1_T - 1.6584965339860827*h1_2_T - 0.21675062922717997*h1_3_T + 0.39340038585118614*h1_4_T + 0.8906320947123818*h1_5_T - 0.23988539949985616*h1_6_T + 0.547954966610345*h1_7_T - 1.0611851455917574*h1_8_T);
      z = 0.4738620533267623 - 0.8773963536685434*h1_1 + 1.9867599449822406*h1_2 + 0.07361831076568875*h1_3 - 0.4827701619951592*h1_4 - 0.07521138549670638*h1_5 + 0.19970082219928553*h1_6 + 0.2491705951139224*h1_7 - 0.602653488022388*h1_8;
      h2_6 = tanh(z);
      h2_6_vgs = (1.0 - h2_6*h2_6)*(- 0.8773963536685434*h1_1_vgs + 1.9867599449822406*h1_2_vgs + 0.07361831076568875*h1_3_vgs - 0.4827701619951592*h1_4_vgs - 0.07521138549670638*h1_5_vgs + 0.19970082219928553*h1_6_vgs + 0.2491705951139224*h1_7_vgs - 0.602653488022388*h1_8_vgs);
      h2_6_vds = (1.0 - h2_6*h2_6)*(- 0.8773963536685434*h1_1_vds + 1.9867599449822406*h1_2_vds + 0.07361831076568875*h1_3_vds - 0.4827701619951592*h1_4_vds - 0.07521138549670638*h1_5_vds + 0.19970082219928553*h1_6_vds + 0.2491705951139224*h1_7_vds - 0.602653488022388*h1_8_vds);
      h2_6_T = (1.0 - h2_6*h2_6)*(- 0.8773963536685434*h1_1_T + 1.9867599449822406*h1_2_T + 0.07361831076568875*h1_3_T - 0.4827701619951592*h1_4_T - 0.07521138549670638*h1_5_T + 0.19970082219928553*h1_6_T + 0.2491705951139224*h1_7_T - 0.602653488022388*h1_8_T);
      z = -0.5575926978364787 + 0.3141123849556959*h1_1 - 0.10995362918793007*h1_2 - 0.10809822583935613*h1_3 + 0.17294110269269686*h1_4 + 0.007080277197003071*h1_5 - 0.12689658715535718*h1_6 - 0.1440910884955583*h1_7 + 0.9680940905441175*h1_8;
      h2_7 = tanh(z);
      h2_7_vgs = (1.0 - h2_7*h2_7)*(0.3141123849556959*h1_1_vgs - 0.10995362918793007*h1_2_vgs - 0.10809822583935613*h1_3_vgs + 0.17294110269269686*h1_4_vgs + 0.007080277197003071*h1_5_vgs - 0.12689658715535718*h1_6_vgs - 0.1440910884955583*h1_7_vgs + 0.9680940905441175*h1_8_vgs);
      h2_7_vds = (1.0 - h2_7*h2_7)*(0.3141123849556959*h1_1_vds - 0.10995362918793007*h1_2_vds - 0.10809822583935613*h1_3_vds + 0.17294110269269686*h1_4_vds + 0.007080277197003071*h1_5_vds - 0.12689658715535718*h1_6_vds - 0.1440910884955583*h1_7_vds + 0.9680940905441175*h1_8_vds);
      h2_7_T = (1.0 - h2_7*h2_7)*(0.3141123849556959*h1_1_T - 0.10995362918793007*h1_2_T - 0.10809822583935613*h1_3_T + 0.17294110269269686*h1_4_T + 0.007080277197003071*h1_5_T - 0.12689658715535718*h1_6_T - 0.1440910884955583*h1_7_T + 0.9680940905441175*h1_8_T);
      z = 0.8447032864059496 + 0.45251468136989453*h1_1 + 0.6003268764457097*h1_2 + 0.1727805887167078*h1_3 + 0.08113203378795272*h1_4 + 0.26253999795299554*h1_5 - 0.31804582738721754*h1_6 - 1.1885448737246078*h1_7 + 1.3643024505925228*h1_8;
      h2_8 = tanh(z);
      h2_8_vgs = (1.0 - h2_8*h2_8)*(0.45251468136989453*h1_1_vgs + 0.6003268764457097*h1_2_vgs + 0.1727805887167078*h1_3_vgs + 0.08113203378795272*h1_4_vgs + 0.26253999795299554*h1_5_vgs - 0.31804582738721754*h1_6_vgs - 1.1885448737246078*h1_7_vgs + 1.3643024505925228*h1_8_vgs);
      h2_8_vds = (1.0 - h2_8*h2_8)*(0.45251468136989453*h1_1_vds + 0.6003268764457097*h1_2_vds + 0.1727805887167078*h1_3_vds + 0.08113203378795272*h1_4_vds + 0.26253999795299554*h1_5_vds - 0.31804582738721754*h1_6_vds - 1.1885448737246078*h1_7_vds + 1.3643024505925228*h1_8_vds);
      h2_8_T = (1.0 - h2_8*h2_8)*(0.45251468136989453*h1_1_T + 0.6003268764457097*h1_2_T + 0.1727805887167078*h1_3_T + 0.08113203378795272*h1_4_T + 0.26253999795299554*h1_5_T - 0.31804582738721754*h1_6_T - 1.1885448737246078*h1_7_T + 1.3643024505925228*h1_8_T);
      // output
      u = -0.1352683009856447 - 0.14958672307798132*h2_1 + 0.5660095555065648*h2_2 - 0.6499896945736368*h2_3 + 1.8323156404733003*h2_4 - 0.4593989494528838*h2_5 - 2.131315306286907*h2_6 + 1.260210161127013*h2_7 + 1.622721543090151*h2_8;
      u_vgs = - 0.14958672307798132*h2_1_vgs + 0.5660095555065648*h2_2_vgs - 0.6499896945736368*h2_3_vgs + 1.8323156404733003*h2_4_vgs - 0.4593989494528838*h2_5_vgs - 2.131315306286907*h2_6_vgs + 1.260210161127013*h2_7_vgs + 1.622721543090151*h2_8_vgs;
      u_vds = - 0.14958672307798132*h2_1_vds + 0.5660095555065648*h2_2_vds - 0.6499896945736368*h2_3_vds + 1.8323156404733003*h2_4_vds - 0.4593989494528838*h2_5_vds - 2.131315306286907*h2_6_vds + 1.260210161127013*h2_7_vds + 1.622721543090151*h2_8_vds;
      u_T = - 0.14958672307798132*h2_1_T + 0.5660095555065648*h2_2_T - 0.6499896945736368*h2_3_T + 1.8323156404733003*h2_4_T - 0.4593989494528838*h2_5_T - 2.131315306286907*h2_6_T + 1.260210161127013*h2_7_T + 1.622721543090151*h2_8_T;
      f_Qd = 0.0 + 1.0700932823311475e-12*u;
      d_vgs = 1.0700932823311475e-12*u_vgs;
      d_vds = 1.0700932823311475e-12*u_vds;
      d_T = 1.0700932823311475e-12*u_T;
    end
  endfunction

  // Core.Constituents.Qd.Network continued outside Core.Constituents.Qd.Domain (guided extrapolation)
  analog function real x_Qd;
    input vgs, vds, T;
    real vgs, vds, T;
    real u_vgs, u_vds, u_T, b_vgs, b_vds, b_T, p_vgs, p_vds, p_T, g_vgs, g_vds, g_T;
    real t, cx, cy, e, best, cr, fb, s, dist2, gl, ga;
    integer inside, inbox;
    begin
      // normalised by the domain's centre and extent
      u_vgs = (vgs - (-0.9208796670951123))/2.1582407449889756;
      u_vds = (vds - 7.566235437630191)/14.867529124463616;
      u_T = (T - 64.251518025185)/78.50303605037001;
      inbox = 1;
      // Domain.Box.T
      if (u_T < (-0.5)) begin b_T = (-0.5); inbox = 0; end
      else if (u_T > 0.5) begin b_T = 0.5; inbox = 0; end
      else b_T = u_T;
      // Domain.Polygon: 10 vertices, counter-clockwise
      inside = 1;
      cr = 0.9945485555180813*(u_vds - (-0.47527975047364995)) - (-0.024720249526350158)*(u_vgs - (-0.5));
      if (cr < 0.0) inside = 0;
      cr = 0.005451444481918644*(u_vds - (-0.5000000000000001)) - 0.0018944617201674951*(u_vgs - 0.49454855551808136);
      if (cr < 0.0) inside = 0;
      cr = (-0.09398705129148938)*(u_vds - (-0.4981055382798326)) - 0.9426177824000829*(u_vgs - 0.5);
      if (cr < 0.0) inside = 0;
      cr = (-0.09249964651191961)*(u_vds - 0.44451224412025026) - 0.016160326304840433*(u_vgs - 0.4060129487085106);
      if (cr < 0.0) inside = 0;
      cr = (-0.13091432540818732)*(u_vds - 0.4606725704250907) - 0.01891242532930726*(u_vgs - 0.313513302196591);
      if (cr < 0.0) inside = 0;
      cr = (-0.14509413109986158)*(u_vds - 0.47958499575439795) - 0.013984722374358438*(u_vgs - 0.1825989767884037);
      if (cr < 0.0) inside = 0;
      cr = (-0.16824602428679386)*(u_vds - 0.4935697181287564) - 0.005939079510797307*(u_vgs - 0.037504845688542135);
      if (cr < 0.0) inside = 0;
      cr = (-0.18393634886175214)*(u_vds - 0.4995087976395537) - 0.00048644775735068313*(u_vgs - (-0.13074117859825174));
      if (cr < 0.0) inside = 0;
      cr = (-0.1853224541917186)*(u_vds - 0.4999952453969044) - 4.754603095624699e-06*(u_vgs - (-0.3146775274600039));
      if (cr < 0.0) inside = 0;
      cr = (-1.834827750846202e-08)*(u_vds - 0.5) - (-0.9752797504736499)*(u_vgs - (-0.4999999816517225));
      if (cr < 0.0) inside = 0;
      if (inside) begin
        b_vgs = u_vgs;
        b_vds = u_vds;
      end else begin
        t = ((u_vgs - (-0.5))*0.9945485555180813 + (u_vds - (-0.47527975047364995))*(-0.024720249526350158))/0.989737920019747;
        if (t < 0.0) t = 0.0; else if (t > 1.0) t = 1.0;
        cx = (-0.5) + t*0.9945485555180813;
        cy = (-0.47527975047364995) + t*(-0.024720249526350158);
        e = (u_vgs - cx)*(u_vgs - cx) + (u_vds - cy)*(u_vds - cy);
        best = e; b_vgs = cx; b_vds = cy;
        t = ((u_vgs - 0.49454855551808136)*0.005451444481918644 + (u_vds - (-0.5000000000000001))*0.0018944617201674951)/3.3307232148621213e-05;
        if (t < 0.0) t = 0.0; else if (t > 1.0) t = 1.0;
        cx = 0.49454855551808136 + t*0.005451444481918644;
        cy = (-0.5000000000000001) + t*0.0018944617201674951;
        e = (u_vgs - cx)*(u_vgs - cx) + (u_vds - cy)*(u_vds - cy);
        if (e < best) begin best = e; b_vgs = cx; b_vds = cy; end
        t = ((u_vgs - 0.5)*(-0.09398705129148938) + (u_vds - (-0.4981055382798326))*0.9426177824000829)/0.897361849507319;
        if (t < 0.0) t = 0.0; else if (t > 1.0) t = 1.0;
        cx = 0.5 + t*(-0.09398705129148938);
        cy = (-0.4981055382798326) + t*0.9426177824000829;
        e = (u_vgs - cx)*(u_vgs - cx) + (u_vds - cy)*(u_vds - cy);
        if (e < best) begin best = e; b_vgs = cx; b_vds = cy; end
        t = ((u_vgs - 0.4060129487085106)*(-0.09249964651191961) + (u_vds - 0.44451224412025026)*0.016160326304840433)/0.008817340751109;
        if (t < 0.0) t = 0.0; else if (t > 1.0) t = 1.0;
        cx = 0.4060129487085106 + t*(-0.09249964651191961);
        cy = 0.44451224412025026 + t*0.016160326304840433;
        e = (u_vgs - cx)*(u_vgs - cx) + (u_vds - cy)*(u_vds - cy);
        if (e < best) begin best = e; b_vgs = cx; b_vds = cy; end
        t = ((u_vgs - 0.313513302196591)*(-0.13091432540818732) + (u_vds - 0.4606725704250907)*0.01891242532930726)/0.017496240428917384;
        if (t < 0.0) t = 0.0; else if (t > 1.0) t = 1.0;
        cx = 0.313513302196591 + t*(-0.13091432540818732);
        cy = 0.4606725704250907 + t*0.01891242532930726;
        e = (u_vgs - cx)*(u_vgs - cx) + (u_vds - cy)*(u_vds - cy);
        if (e < best) begin best = e; b_vgs = cx; b_vds = cy; end
        t = ((u_vgs - 0.1825989767884037)*(-0.14509413109986158) + (u_vds - 0.47958499575439795)*0.013984722374358438)/0.0212478793395117;
        if (t < 0.0) t = 0.0; else if (t > 1.0) t = 1.0;
        cx = 0.1825989767884037 + t*(-0.14509413109986158);
        cy = 0.47958499575439795 + t*0.013984722374358438;
        e = (u_vgs - cx)*(u_vgs - cx) + (u_vds - cy)*(u_vds - cy);
        if (e < best) begin best = e; b_vgs = cx; b_vds = cy; end
        t = ((u_vgs - 0.037504845688542135)*(-0.16824602428679386) + (u_vds - 0.4935697181287564)*0.005939079510797307)/0.028341997353748004;
        if (t < 0.0) t = 0.0; else if (t > 1.0) t = 1.0;
        cx = 0.037504845688542135 + t*(-0.16824602428679386);
        cy = 0.4935697181287564 + t*0.005939079510797307;
        e = (u_vgs - cx)*(u_vgs - cx) + (u_vds - cy)*(u_vds - cy);
        if (e < best) begin best = e; b_vgs = cx; b_vds = cy; end
        t = ((u_vgs - (-0.13074117859825174))*(-0.18393634886175214) + (u_vds - 0.4995087976395537)*0.00048644775735068313)/0.03383281706401282;
        if (t < 0.0) t = 0.0; else if (t > 1.0) t = 1.0;
        cx = (-0.13074117859825174) + t*(-0.18393634886175214);
        cy = 0.4995087976395537 + t*0.00048644775735068313;
        e = (u_vgs - cx)*(u_vgs - cx) + (u_vds - cy)*(u_vds - cy);
        if (e < best) begin best = e; b_vgs = cx; b_vds = cy; end
        t = ((u_vgs - (-0.3146775274600039))*(-0.1853224541917186) + (u_vds - 0.4999952453969044)*4.754603095624699e-06)/0.034344412050247894;
        if (t < 0.0) t = 0.0; else if (t > 1.0) t = 1.0;
        cx = (-0.3146775274600039) + t*(-0.1853224541917186);
        cy = 0.4999952453969044 + t*4.754603095624699e-06;
        e = (u_vgs - cx)*(u_vgs - cx) + (u_vds - cy)*(u_vds - cy);
        if (e < best) begin best = e; b_vgs = cx; b_vds = cy; end
        t = ((u_vgs - (-0.4999999816517225))*(-1.834827750846202e-08) + (u_vds - 0.5)*(-0.9752797504736499))/0.9511705916839451;
        if (t < 0.0) t = 0.0; else if (t > 1.0) t = 1.0;
        cx = (-0.4999999816517225) + t*(-1.834827750846202e-08);
        cy = 0.5 + t*(-0.9752797504736499);
        e = (u_vgs - cx)*(u_vgs - cx) + (u_vds - cy)*(u_vds - cy);
        if (e < best) begin best = e; b_vgs = cx; b_vds = cy; end
      end
      // the nearest domain point: the point itself inside, else back from normalised coordinates
      if (inside && inbox) begin
        p_vgs = vgs;
        p_vds = vds;
        p_T = T;
      end else begin
        p_vgs = (-0.9208796670951123) + 2.1582407449889756*b_vgs;
        p_vds = 7.566235437630191 + 14.867529124463616*b_vds;
        p_T = 64.251518025185 + 78.50303605037001*b_T;
      end
      fb = f_Qd(p_vgs, p_vds, p_T, g_vgs, g_vds, g_T);
      x_Qd = fb + g_vgs*(vgs - p_vgs) + g_vds*(vds - p_vds) + g_T*(T - p_T);
    end
  endfunction

  // Traps (CaptureEmission) drain-lag phi2: emission towards vds, capture upwards; dphi/dt in V/s
  analog function real r_phi2;
    input ph, vgs, vds, T;
    real ph, vgs, vds, T;
    real x, u, ex, f, re, tk, tr;
    begin
      x = vds - ph;
      u = (x - Xref)/Vc;
      if (u <= 20.0) ex = exp(u);
      else ex = exp(20.0)*(1.0 + (u - 20.0));
      f = (Xref/TauCapt2)*(ex - exp(-Xref/Vc));
      re = 1.0/TauEmit2;
      r_phi2 = (vds - ph)*re + f;
    end
  endfunction

  // Traps (CaptureEmission) phi2's DC value: vds
  analog function real dc_phi2;
    input vgs, vds, T;
    real vgs, vds, T;
    begin
      dc_phi2 = vds;
    end
  endfunction

  // Core.Constituents.Qg.Network with its Hessian along a direction
  analog function real fh_Qg;
    input vgs, vds, T, w_vgs, w_vds, w_T;
    output d_vgs, d_vds, d_T, hw_vgs, hw_vds, hw_T;
    real vgs, vds, T, w_vgs, w_vds, w_T;
    real d_vgs, d_vds, d_T, hw_vgs, hw_vds, hw_T;
    real z, zw, sl, slw, zg_vgs, zgw_vgs, zg_vds, zgw_vds, zg_T, zgw_T, x1, x1_w;
    real x2, x2_w, x3, x3_w, h1_1, h1_1_w, h1_1_vgs, h1_1_vgs_w, h1_1_vds, h1_1_vds_w, h1_1_T, h1_1_T_w;
    real h1_2, h1_2_w, h1_2_vgs, h1_2_vgs_w, h1_2_vds, h1_2_vds_w, h1_2_T, h1_2_T_w, h1_3, h1_3_w, h1_3_vgs, h1_3_vgs_w;
    real h1_3_vds, h1_3_vds_w, h1_3_T, h1_3_T_w, h1_4, h1_4_w, h1_4_vgs, h1_4_vgs_w, h1_4_vds, h1_4_vds_w, h1_4_T, h1_4_T_w;
    real h1_5, h1_5_w, h1_5_vgs, h1_5_vgs_w, h1_5_vds, h1_5_vds_w, h1_5_T, h1_5_T_w, h1_6, h1_6_w, h1_6_vgs, h1_6_vgs_w;
    real h1_6_vds, h1_6_vds_w, h1_6_T, h1_6_T_w, h1_7, h1_7_w, h1_7_vgs, h1_7_vgs_w, h1_7_vds, h1_7_vds_w, h1_7_T, h1_7_T_w;
    real h1_8, h1_8_w, h1_8_vgs, h1_8_vgs_w, h1_8_vds, h1_8_vds_w, h1_8_T, h1_8_T_w, h2_1, h2_1_w, h2_1_vgs, h2_1_vgs_w;
    real h2_1_vds, h2_1_vds_w, h2_1_T, h2_1_T_w, h2_2, h2_2_w, h2_2_vgs, h2_2_vgs_w, h2_2_vds, h2_2_vds_w, h2_2_T, h2_2_T_w;
    real h2_3, h2_3_w, h2_3_vgs, h2_3_vgs_w, h2_3_vds, h2_3_vds_w, h2_3_T, h2_3_T_w, h2_4, h2_4_w, h2_4_vgs, h2_4_vgs_w;
    real h2_4_vds, h2_4_vds_w, h2_4_T, h2_4_T_w, h2_5, h2_5_w, h2_5_vgs, h2_5_vgs_w, h2_5_vds, h2_5_vds_w, h2_5_T, h2_5_T_w;
    real h2_6, h2_6_w, h2_6_vgs, h2_6_vgs_w, h2_6_vds, h2_6_vds_w, h2_6_T, h2_6_T_w, h2_7, h2_7_w, h2_7_vgs, h2_7_vgs_w;
    real h2_7_vds, h2_7_vds_w, h2_7_T, h2_7_T_w, h2_8, h2_8_w, h2_8_vgs, h2_8_vgs_w, h2_8_vds, h2_8_vds_w, h2_8_T, h2_8_T_w;
    real u, u_w, u_vgs, u_vgs_w, u_vds, u_vds_w, u_T, u_T_w;
    begin
      x1 = (vgs - (-0.9208796670951123))*0.9266806794578499;
      x1_w = w_vgs*0.9266806794578499;
      x2 = (vds - 7.566235437630191)*0.13452134401466356;
      x2_w = w_vds*0.13452134401466356;
      x3 = (T - 64.251518025185)*0.025476721673754595;
      x3_w = w_T*0.025476721673754595;
      // hidden layer 1
      z = -0.3637558756015876 + 0.3453732192212337*x1 - 0.9923288740271166*x2 - 0.001587595315250342*x3;
      zw = 0.3453732192212337*x1_w - 0.9923288740271166*x2_w - 0.001587595315250342*x3_w;
      zg_vgs = 0.3200506894544778;
      zgw_vgs = 0.0;
      zg_vds = -0.13348941383868548;
      zgw_vds = 0.0;
      zg_T = -4.0446723977189646e-05;
      zgw_T = 0.0;
      h1_1 = tanh(z);
      sl = (1.0 - h1_1*h1_1);
      h1_1_w = sl*zw;
      slw = -2.0*h1_1*h1_1_w;
      h1_1_vgs = sl*(zg_vgs);
      h1_1_vgs_w = sl*zgw_vgs + slw*zg_vgs;
      h1_1_vds = sl*(zg_vds);
      h1_1_vds_w = sl*zgw_vds + slw*zg_vds;
      h1_1_T = sl*(zg_T);
      h1_1_T_w = sl*zgw_T + slw*zg_T;
      z = -0.4523139241991508 - 0.010387229619475453*x1 + 0.24241398536256417*x2 - 0.023192819534764087*x3;
      zw = - 0.010387229619475453*x1_w + 0.24241398536256417*x2_w - 0.023192819534764087*x3_w;
      zg_vgs = -0.009625645001460218;
      zgw_vgs = 0.0;
      zg_vds = 0.032609855118923115;
      zgw_vds = 0.0;
      zg_T = -0.0005908770081168032;
      zgw_T = 0.0;
      h1_2 = tanh(z);
      sl = (1.0 - h1_2*h1_2);
      h1_2_w = sl*zw;
      slw = -2.0*h1_2*h1_2_w;
      h1_2_vgs = sl*(zg_vgs);
      h1_2_vgs_w = sl*zgw_vgs + slw*zg_vgs;
      h1_2_vds = sl*(zg_vds);
      h1_2_vds_w = sl*zgw_vds + slw*zg_vds;
      h1_2_T = sl*(zg_T);
      h1_2_T_w = sl*zgw_T + slw*zg_T;
      z = 0.6442247132203237 + 0.16293509387018987*x1 - 0.5944491844924036*x2 - 0.002486632830012602*x3;
      zw = 0.16293509387018987*x1_w - 0.5944491844924036*x2_w - 0.002486632830012602*x3_w;
      zg_vgs = 0.15098880349515612;
      zgw_vgs = 0.0;
      zg_vds = -0.07996610324633883;
      zgw_vds = 0.0;
      zg_T = -6.335125251505178e-05;
      zgw_T = 0.0;
      h1_3 = tanh(z);
      sl = (1.0 - h1_3*h1_3);
      h1_3_w = sl*zw;
      slw = -2.0*h1_3*h1_3_w;
      h1_3_vgs = sl*(zg_vgs);
      h1_3_vgs_w = sl*zgw_vgs + slw*zg_vgs;
      h1_3_vds = sl*(zg_vds);
      h1_3_vds_w = sl*zgw_vds + slw*zg_vds;
      h1_3_T = sl*(zg_T);
      h1_3_T_w = sl*zgw_T + slw*zg_T;
      z = -1.3114370475934891 + 0.02692120073969437*x1 + 0.09253928310735786*x2 + 0.04006380311878135*x3;
      zw = 0.02692120073969437*x1_w + 0.09253928310735786*x2_w + 0.04006380311878135*x3_w;
      zg_vgs = 0.02494735659328115;
      zgw_vgs = 0.0;
      zg_vds = 0.01244850873775523;
      zgw_vds = 0.0;
      zg_T = 0.0010206943612492937;
      zgw_T = 0.0;
      h1_4 = tanh(z);
      sl = (1.0 - h1_4*h1_4);
      h1_4_w = sl*zw;
      slw = -2.0*h1_4*h1_4_w;
      h1_4_vgs = sl*(zg_vgs);
      h1_4_vgs_w = sl*zgw_vgs + slw*zg_vgs;
      h1_4_vds = sl*(zg_vds);
      h1_4_vds_w = sl*zgw_vds + slw*zg_vds;
      h1_4_T = sl*(zg_T);
      h1_4_T_w = sl*zgw_T + slw*zg_T;
      z = -1.249087070917115 + 0.16442250518824908*x1 - 1.3755190188252502*x2 + 0.0011040884110266494*x3;
      zw = 0.16442250518824908*x1_w - 1.3755190188252502*x2_w + 0.0011040884110266494*x3_w;
      zg_vgs = 0.15236715882600851;
      zgw_vgs = 0.0;
      zg_vds = -0.18503666713010397;
      zgw_vds = 0.0;
      zg_T = 2.812855315094391e-05;
      zgw_T = 0.0;
      h1_5 = tanh(z);
      sl = (1.0 - h1_5*h1_5);
      h1_5_w = sl*zw;
      slw = -2.0*h1_5*h1_5_w;
      h1_5_vgs = sl*(zg_vgs);
      h1_5_vgs_w = sl*zgw_vgs + slw*zg_vgs;
      h1_5_vds = sl*(zg_vds);
      h1_5_vds_w = sl*zgw_vds + slw*zg_vds;
      h1_5_T = sl*(zg_T);
      h1_5_T_w = sl*zgw_T + slw*zg_T;
      z = -0.6180488993017487 - 0.03831384840204116*x1 - 0.3528131021219113*x2 + 0.0014055580820843457*x3;
      zw = - 0.03831384840204116*x1_w - 0.3528131021219113*x2_w + 0.0014055580820843457*x3_w;
      zg_vgs = -0.03550470306984856;
      zgw_vgs = 0.0;
      zg_vds = -0.04746089268342226;
      zgw_vds = 0.0;
      zg_T = 3.580901205355919e-05;
      zgw_T = 0.0;
      h1_6 = tanh(z);
      sl = (1.0 - h1_6*h1_6);
      h1_6_w = sl*zw;
      slw = -2.0*h1_6*h1_6_w;
      h1_6_vgs = sl*(zg_vgs);
      h1_6_vgs_w = sl*zgw_vgs + slw*zg_vgs;
      h1_6_vds = sl*(zg_vds);
      h1_6_vds_w = sl*zgw_vds + slw*zg_vds;
      h1_6_T = sl*(zg_T);
      h1_6_T_w = sl*zgw_T + slw*zg_T;
      z = 1.1626534001066242 + 0.4629830883804438*x1 + 0.432175265200138*x2 - 0.0008484417497798104*x3;
      zw = 0.4629830883804438*x1_w + 0.432175265200138*x2_w - 0.0008484417497798104*x3_w;
      zg_vgs = 0.4290374829178834;
      zgw_vgs = 0.0;
      zg_vds = 0.05813679752461622;
      zgw_vds = 0.0;
      zg_T = -2.1615514315533568e-05;
      zgw_T = 0.0;
      h1_7 = tanh(z);
      sl = (1.0 - h1_7*h1_7);
      h1_7_w = sl*zw;
      slw = -2.0*h1_7*h1_7_w;
      h1_7_vgs = sl*(zg_vgs);
      h1_7_vgs_w = sl*zgw_vgs + slw*zg_vgs;
      h1_7_vds = sl*(zg_vds);
      h1_7_vds_w = sl*zgw_vds + slw*zg_vds;
      h1_7_T = sl*(zg_T);
      h1_7_T_w = sl*zgw_T + slw*zg_T;
      z = -0.29015865381605854 + 0.14021259943517947*x1 + 0.21170398755128278*x2 - 0.004747408866676142*x3;
      zw = 0.14021259943517947*x1_w + 0.21170398755128278*x2_w - 0.004747408866676142*x3_w;
      zg_vgs = 0.12993230691314345;
      zgw_vgs = 0.0;
      zg_vds = 0.028478704938662162;
      zgw_vds = 0.0;
      zg_T = -0.0001209484143678228;
      zgw_T = 0.0;
      h1_8 = tanh(z);
      sl = (1.0 - h1_8*h1_8);
      h1_8_w = sl*zw;
      slw = -2.0*h1_8*h1_8_w;
      h1_8_vgs = sl*(zg_vgs);
      h1_8_vgs_w = sl*zgw_vgs + slw*zg_vgs;
      h1_8_vds = sl*(zg_vds);
      h1_8_vds_w = sl*zgw_vds + slw*zg_vds;
      h1_8_T = sl*(zg_T);
      h1_8_T_w = sl*zgw_T + slw*zg_T;
      // hidden layer 2
      z = 0.4709736280025499 + 0.11962256917211803*h1_1 - 0.09445857733360931*h1_2 + 0.0321853101971133*h1_3 - 0.25704741640122697*h1_4 - 0.41259658642532976*h1_5 + 0.9373006104497028*h1_6 - 0.23570816114715426*h1_7 - 0.24605094393764962*h1_8;
      zw = 0.11962256917211803*h1_1_w - 0.09445857733360931*h1_2_w + 0.0321853101971133*h1_3_w - 0.25704741640122697*h1_4_w - 0.41259658642532976*h1_5_w + 0.9373006104497028*h1_6_w - 0.23570816114715426*h1_7_w - 0.24605094393764962*h1_8_w;
      zg_vgs = 0.11962256917211803*h1_1_vgs - 0.09445857733360931*h1_2_vgs + 0.0321853101971133*h1_3_vgs - 0.25704741640122697*h1_4_vgs - 0.41259658642532976*h1_5_vgs + 0.9373006104497028*h1_6_vgs - 0.23570816114715426*h1_7_vgs - 0.24605094393764962*h1_8_vgs;
      zgw_vgs = 0.11962256917211803*h1_1_vgs_w - 0.09445857733360931*h1_2_vgs_w + 0.0321853101971133*h1_3_vgs_w - 0.25704741640122697*h1_4_vgs_w - 0.41259658642532976*h1_5_vgs_w + 0.9373006104497028*h1_6_vgs_w - 0.23570816114715426*h1_7_vgs_w - 0.24605094393764962*h1_8_vgs_w;
      zg_vds = 0.11962256917211803*h1_1_vds - 0.09445857733360931*h1_2_vds + 0.0321853101971133*h1_3_vds - 0.25704741640122697*h1_4_vds - 0.41259658642532976*h1_5_vds + 0.9373006104497028*h1_6_vds - 0.23570816114715426*h1_7_vds - 0.24605094393764962*h1_8_vds;
      zgw_vds = 0.11962256917211803*h1_1_vds_w - 0.09445857733360931*h1_2_vds_w + 0.0321853101971133*h1_3_vds_w - 0.25704741640122697*h1_4_vds_w - 0.41259658642532976*h1_5_vds_w + 0.9373006104497028*h1_6_vds_w - 0.23570816114715426*h1_7_vds_w - 0.24605094393764962*h1_8_vds_w;
      zg_T = 0.11962256917211803*h1_1_T - 0.09445857733360931*h1_2_T + 0.0321853101971133*h1_3_T - 0.25704741640122697*h1_4_T - 0.41259658642532976*h1_5_T + 0.9373006104497028*h1_6_T - 0.23570816114715426*h1_7_T - 0.24605094393764962*h1_8_T;
      zgw_T = 0.11962256917211803*h1_1_T_w - 0.09445857733360931*h1_2_T_w + 0.0321853101971133*h1_3_T_w - 0.25704741640122697*h1_4_T_w - 0.41259658642532976*h1_5_T_w + 0.9373006104497028*h1_6_T_w - 0.23570816114715426*h1_7_T_w - 0.24605094393764962*h1_8_T_w;
      h2_1 = tanh(z);
      sl = (1.0 - h2_1*h2_1);
      h2_1_w = sl*zw;
      slw = -2.0*h2_1*h2_1_w;
      h2_1_vgs = sl*(zg_vgs);
      h2_1_vgs_w = sl*zgw_vgs + slw*zg_vgs;
      h2_1_vds = sl*(zg_vds);
      h2_1_vds_w = sl*zgw_vds + slw*zg_vds;
      h2_1_T = sl*(zg_T);
      h2_1_T_w = sl*zgw_T + slw*zg_T;
      z = 0.4457696589319789 + 0.46751504547811285*h1_1 - 0.5305340982149718*h1_2 + 0.9552119799861979*h1_3 - 0.4228561515691911*h1_4 + 0.04898101823307815*h1_5 - 0.3698843441076933*h1_6 + 0.20117935381441887*h1_7 + 0.2882850152581487*h1_8;
      zw = 0.46751504547811285*h1_1_w - 0.5305340982149718*h1_2_w + 0.9552119799861979*h1_3_w - 0.4228561515691911*h1_4_w + 0.04898101823307815*h1_5_w - 0.3698843441076933*h1_6_w + 0.20117935381441887*h1_7_w + 0.2882850152581487*h1_8_w;
      zg_vgs = 0.46751504547811285*h1_1_vgs - 0.5305340982149718*h1_2_vgs + 0.9552119799861979*h1_3_vgs - 0.4228561515691911*h1_4_vgs + 0.04898101823307815*h1_5_vgs - 0.3698843441076933*h1_6_vgs + 0.20117935381441887*h1_7_vgs + 0.2882850152581487*h1_8_vgs;
      zgw_vgs = 0.46751504547811285*h1_1_vgs_w - 0.5305340982149718*h1_2_vgs_w + 0.9552119799861979*h1_3_vgs_w - 0.4228561515691911*h1_4_vgs_w + 0.04898101823307815*h1_5_vgs_w - 0.3698843441076933*h1_6_vgs_w + 0.20117935381441887*h1_7_vgs_w + 0.2882850152581487*h1_8_vgs_w;
      zg_vds = 0.46751504547811285*h1_1_vds - 0.5305340982149718*h1_2_vds + 0.9552119799861979*h1_3_vds - 0.4228561515691911*h1_4_vds + 0.04898101823307815*h1_5_vds - 0.3698843441076933*h1_6_vds + 0.20117935381441887*h1_7_vds + 0.2882850152581487*h1_8_vds;
      zgw_vds = 0.46751504547811285*h1_1_vds_w - 0.5305340982149718*h1_2_vds_w + 0.9552119799861979*h1_3_vds_w - 0.4228561515691911*h1_4_vds_w + 0.04898101823307815*h1_5_vds_w - 0.3698843441076933*h1_6_vds_w + 0.20117935381441887*h1_7_vds_w + 0.2882850152581487*h1_8_vds_w;
      zg_T = 0.46751504547811285*h1_1_T - 0.5305340982149718*h1_2_T + 0.9552119799861979*h1_3_T - 0.4228561515691911*h1_4_T + 0.04898101823307815*h1_5_T - 0.3698843441076933*h1_6_T + 0.20117935381441887*h1_7_T + 0.2882850152581487*h1_8_T;
      zgw_T = 0.46751504547811285*h1_1_T_w - 0.5305340982149718*h1_2_T_w + 0.9552119799861979*h1_3_T_w - 0.4228561515691911*h1_4_T_w + 0.04898101823307815*h1_5_T_w - 0.3698843441076933*h1_6_T_w + 0.20117935381441887*h1_7_T_w + 0.2882850152581487*h1_8_T_w;
      h2_2 = tanh(z);
      sl = (1.0 - h2_2*h2_2);
      h2_2_w = sl*zw;
      slw = -2.0*h2_2*h2_2_w;
      h2_2_vgs = sl*(zg_vgs);
      h2_2_vgs_w = sl*zgw_vgs + slw*zg_vgs;
      h2_2_vds = sl*(zg_vds);
      h2_2_vds_w = sl*zgw_vds + slw*zg_vds;
      h2_2_T = sl*(zg_T);
      h2_2_T_w = sl*zgw_T + slw*zg_T;
      z = -0.05889011962713903 + 0.04069818361783333*h1_1 + 0.035732027825172444*h1_2 - 0.2958719774084451*h1_3 - 0.2833113221669226*h1_4 - 0.1967053371879806*h1_5 - 0.20507874292595768*h1_6 - 0.27272084603876934*h1_7 - 0.5719528065403512*h1_8;
      zw = 0.04069818361783333*h1_1_w + 0.035732027825172444*h1_2_w - 0.2958719774084451*h1_3_w - 0.2833113221669226*h1_4_w - 0.1967053371879806*h1_5_w - 0.20507874292595768*h1_6_w - 0.27272084603876934*h1_7_w - 0.5719528065403512*h1_8_w;
      zg_vgs = 0.04069818361783333*h1_1_vgs + 0.035732027825172444*h1_2_vgs - 0.2958719774084451*h1_3_vgs - 0.2833113221669226*h1_4_vgs - 0.1967053371879806*h1_5_vgs - 0.20507874292595768*h1_6_vgs - 0.27272084603876934*h1_7_vgs - 0.5719528065403512*h1_8_vgs;
      zgw_vgs = 0.04069818361783333*h1_1_vgs_w + 0.035732027825172444*h1_2_vgs_w - 0.2958719774084451*h1_3_vgs_w - 0.2833113221669226*h1_4_vgs_w - 0.1967053371879806*h1_5_vgs_w - 0.20507874292595768*h1_6_vgs_w - 0.27272084603876934*h1_7_vgs_w - 0.5719528065403512*h1_8_vgs_w;
      zg_vds = 0.04069818361783333*h1_1_vds + 0.035732027825172444*h1_2_vds - 0.2958719774084451*h1_3_vds - 0.2833113221669226*h1_4_vds - 0.1967053371879806*h1_5_vds - 0.20507874292595768*h1_6_vds - 0.27272084603876934*h1_7_vds - 0.5719528065403512*h1_8_vds;
      zgw_vds = 0.04069818361783333*h1_1_vds_w + 0.035732027825172444*h1_2_vds_w - 0.2958719774084451*h1_3_vds_w - 0.2833113221669226*h1_4_vds_w - 0.1967053371879806*h1_5_vds_w - 0.20507874292595768*h1_6_vds_w - 0.27272084603876934*h1_7_vds_w - 0.5719528065403512*h1_8_vds_w;
      zg_T = 0.04069818361783333*h1_1_T + 0.035732027825172444*h1_2_T - 0.2958719774084451*h1_3_T - 0.2833113221669226*h1_4_T - 0.1967053371879806*h1_5_T - 0.20507874292595768*h1_6_T - 0.27272084603876934*h1_7_T - 0.5719528065403512*h1_8_T;
      zgw_T = 0.04069818361783333*h1_1_T_w + 0.035732027825172444*h1_2_T_w - 0.2958719774084451*h1_3_T_w - 0.2833113221669226*h1_4_T_w - 0.1967053371879806*h1_5_T_w - 0.20507874292595768*h1_6_T_w - 0.27272084603876934*h1_7_T_w - 0.5719528065403512*h1_8_T_w;
      h2_3 = tanh(z);
      sl = (1.0 - h2_3*h2_3);
      h2_3_w = sl*zw;
      slw = -2.0*h2_3*h2_3_w;
      h2_3_vgs = sl*(zg_vgs);
      h2_3_vgs_w = sl*zgw_vgs + slw*zg_vgs;
      h2_3_vds = sl*(zg_vds);
      h2_3_vds_w = sl*zgw_vds + slw*zg_vds;
      h2_3_T = sl*(zg_T);
      h2_3_T_w = sl*zgw_T + slw*zg_T;
      z = -0.594891706772195 + 0.7422370021686616*h1_1 + 0.26735252942272925*h1_2 - 0.04101194110968366*h1_3 + 0.4022235253705055*h1_4 + 0.14130062698376772*h1_5 - 1.2806976967038375*h1_6 + 0.020282818097082593*h1_7 + 0.7405443249406135*h1_8;
      zw = 0.7422370021686616*h1_1_w + 0.26735252942272925*h1_2_w - 0.04101194110968366*h1_3_w + 0.4022235253705055*h1_4_w + 0.14130062698376772*h1_5_w - 1.2806976967038375*h1_6_w + 0.020282818097082593*h1_7_w + 0.7405443249406135*h1_8_w;
      zg_vgs = 0.7422370021686616*h1_1_vgs + 0.26735252942272925*h1_2_vgs - 0.04101194110968366*h1_3_vgs + 0.4022235253705055*h1_4_vgs + 0.14130062698376772*h1_5_vgs - 1.2806976967038375*h1_6_vgs + 0.020282818097082593*h1_7_vgs + 0.7405443249406135*h1_8_vgs;
      zgw_vgs = 0.7422370021686616*h1_1_vgs_w + 0.26735252942272925*h1_2_vgs_w - 0.04101194110968366*h1_3_vgs_w + 0.4022235253705055*h1_4_vgs_w + 0.14130062698376772*h1_5_vgs_w - 1.2806976967038375*h1_6_vgs_w + 0.020282818097082593*h1_7_vgs_w + 0.7405443249406135*h1_8_vgs_w;
      zg_vds = 0.7422370021686616*h1_1_vds + 0.26735252942272925*h1_2_vds - 0.04101194110968366*h1_3_vds + 0.4022235253705055*h1_4_vds + 0.14130062698376772*h1_5_vds - 1.2806976967038375*h1_6_vds + 0.020282818097082593*h1_7_vds + 0.7405443249406135*h1_8_vds;
      zgw_vds = 0.7422370021686616*h1_1_vds_w + 0.26735252942272925*h1_2_vds_w - 0.04101194110968366*h1_3_vds_w + 0.4022235253705055*h1_4_vds_w + 0.14130062698376772*h1_5_vds_w - 1.2806976967038375*h1_6_vds_w + 0.020282818097082593*h1_7_vds_w + 0.7405443249406135*h1_8_vds_w;
      zg_T = 0.7422370021686616*h1_1_T + 0.26735252942272925*h1_2_T - 0.04101194110968366*h1_3_T + 0.4022235253705055*h1_4_T + 0.14130062698376772*h1_5_T - 1.2806976967038375*h1_6_T + 0.020282818097082593*h1_7_T + 0.7405443249406135*h1_8_T;
      zgw_T = 0.7422370021686616*h1_1_T_w + 0.26735252942272925*h1_2_T_w - 0.04101194110968366*h1_3_T_w + 0.4022235253705055*h1_4_T_w + 0.14130062698376772*h1_5_T_w - 1.2806976967038375*h1_6_T_w + 0.020282818097082593*h1_7_T_w + 0.7405443249406135*h1_8_T_w;
      h2_4 = tanh(z);
      sl = (1.0 - h2_4*h2_4);
      h2_4_w = sl*zw;
      slw = -2.0*h2_4*h2_4_w;
      h2_4_vgs = sl*(zg_vgs);
      h2_4_vgs_w = sl*zgw_vgs + slw*zg_vgs;
      h2_4_vds = sl*(zg_vds);
      h2_4_vds_w = sl*zgw_vds + slw*zg_vds;
      h2_4_T = sl*(zg_T);
      h2_4_T_w = sl*zgw_T + slw*zg_T;
      z = 0.017413852666497167 + 0.36478592458952636*h1_1 - 0.30493639886403545*h1_2 + 0.09936984043464762*h1_3 + 0.1929697996366971*h1_4 + 0.514433986828323*h1_5 - 0.29957874466843804*h1_6 - 0.563379458266838*h1_7 - 0.36759545438246277*h1_8;
      zw = 0.36478592458952636*h1_1_w - 0.30493639886403545*h1_2_w + 0.09936984043464762*h1_3_w + 0.1929697996366971*h1_4_w + 0.514433986828323*h1_5_w - 0.29957874466843804*h1_6_w - 0.563379458266838*h1_7_w - 0.36759545438246277*h1_8_w;
      zg_vgs = 0.36478592458952636*h1_1_vgs - 0.30493639886403545*h1_2_vgs + 0.09936984043464762*h1_3_vgs + 0.1929697996366971*h1_4_vgs + 0.514433986828323*h1_5_vgs - 0.29957874466843804*h1_6_vgs - 0.563379458266838*h1_7_vgs - 0.36759545438246277*h1_8_vgs;
      zgw_vgs = 0.36478592458952636*h1_1_vgs_w - 0.30493639886403545*h1_2_vgs_w + 0.09936984043464762*h1_3_vgs_w + 0.1929697996366971*h1_4_vgs_w + 0.514433986828323*h1_5_vgs_w - 0.29957874466843804*h1_6_vgs_w - 0.563379458266838*h1_7_vgs_w - 0.36759545438246277*h1_8_vgs_w;
      zg_vds = 0.36478592458952636*h1_1_vds - 0.30493639886403545*h1_2_vds + 0.09936984043464762*h1_3_vds + 0.1929697996366971*h1_4_vds + 0.514433986828323*h1_5_vds - 0.29957874466843804*h1_6_vds - 0.563379458266838*h1_7_vds - 0.36759545438246277*h1_8_vds;
      zgw_vds = 0.36478592458952636*h1_1_vds_w - 0.30493639886403545*h1_2_vds_w + 0.09936984043464762*h1_3_vds_w + 0.1929697996366971*h1_4_vds_w + 0.514433986828323*h1_5_vds_w - 0.29957874466843804*h1_6_vds_w - 0.563379458266838*h1_7_vds_w - 0.36759545438246277*h1_8_vds_w;
      zg_T = 0.36478592458952636*h1_1_T - 0.30493639886403545*h1_2_T + 0.09936984043464762*h1_3_T + 0.1929697996366971*h1_4_T + 0.514433986828323*h1_5_T - 0.29957874466843804*h1_6_T - 0.563379458266838*h1_7_T - 0.36759545438246277*h1_8_T;
      zgw_T = 0.36478592458952636*h1_1_T_w - 0.30493639886403545*h1_2_T_w + 0.09936984043464762*h1_3_T_w + 0.1929697996366971*h1_4_T_w + 0.514433986828323*h1_5_T_w - 0.29957874466843804*h1_6_T_w - 0.563379458266838*h1_7_T_w - 0.36759545438246277*h1_8_T_w;
      h2_5 = tanh(z);
      sl = (1.0 - h2_5*h2_5);
      h2_5_w = sl*zw;
      slw = -2.0*h2_5*h2_5_w;
      h2_5_vgs = sl*(zg_vgs);
      h2_5_vgs_w = sl*zgw_vgs + slw*zg_vgs;
      h2_5_vds = sl*(zg_vds);
      h2_5_vds_w = sl*zgw_vds + slw*zg_vds;
      h2_5_T = sl*(zg_T);
      h2_5_T_w = sl*zgw_T + slw*zg_T;
      z = 0.09587755103398453 - 0.8234570989892074*h1_1 - 0.10059569848973306*h1_2 - 0.7856442965983007*h1_3 - 0.3651345164063168*h1_4 + 0.9242554167158669*h1_5 + 0.6989364419589107*h1_6 - 0.036829021081949596*h1_7 - 0.40951951354784777*h1_8;
      zw = - 0.8234570989892074*h1_1_w - 0.10059569848973306*h1_2_w - 0.7856442965983007*h1_3_w - 0.3651345164063168*h1_4_w + 0.9242554167158669*h1_5_w + 0.6989364419589107*h1_6_w - 0.036829021081949596*h1_7_w - 0.40951951354784777*h1_8_w;
      zg_vgs = - 0.8234570989892074*h1_1_vgs - 0.10059569848973306*h1_2_vgs - 0.7856442965983007*h1_3_vgs - 0.3651345164063168*h1_4_vgs + 0.9242554167158669*h1_5_vgs + 0.6989364419589107*h1_6_vgs - 0.036829021081949596*h1_7_vgs - 0.40951951354784777*h1_8_vgs;
      zgw_vgs = - 0.8234570989892074*h1_1_vgs_w - 0.10059569848973306*h1_2_vgs_w - 0.7856442965983007*h1_3_vgs_w - 0.3651345164063168*h1_4_vgs_w + 0.9242554167158669*h1_5_vgs_w + 0.6989364419589107*h1_6_vgs_w - 0.036829021081949596*h1_7_vgs_w - 0.40951951354784777*h1_8_vgs_w;
      zg_vds = - 0.8234570989892074*h1_1_vds - 0.10059569848973306*h1_2_vds - 0.7856442965983007*h1_3_vds - 0.3651345164063168*h1_4_vds + 0.9242554167158669*h1_5_vds + 0.6989364419589107*h1_6_vds - 0.036829021081949596*h1_7_vds - 0.40951951354784777*h1_8_vds;
      zgw_vds = - 0.8234570989892074*h1_1_vds_w - 0.10059569848973306*h1_2_vds_w - 0.7856442965983007*h1_3_vds_w - 0.3651345164063168*h1_4_vds_w + 0.9242554167158669*h1_5_vds_w + 0.6989364419589107*h1_6_vds_w - 0.036829021081949596*h1_7_vds_w - 0.40951951354784777*h1_8_vds_w;
      zg_T = - 0.8234570989892074*h1_1_T - 0.10059569848973306*h1_2_T - 0.7856442965983007*h1_3_T - 0.3651345164063168*h1_4_T + 0.9242554167158669*h1_5_T + 0.6989364419589107*h1_6_T - 0.036829021081949596*h1_7_T - 0.40951951354784777*h1_8_T;
      zgw_T = - 0.8234570989892074*h1_1_T_w - 0.10059569848973306*h1_2_T_w - 0.7856442965983007*h1_3_T_w - 0.3651345164063168*h1_4_T_w + 0.9242554167158669*h1_5_T_w + 0.6989364419589107*h1_6_T_w - 0.036829021081949596*h1_7_T_w - 0.40951951354784777*h1_8_T_w;
      h2_6 = tanh(z);
      sl = (1.0 - h2_6*h2_6);
      h2_6_w = sl*zw;
      slw = -2.0*h2_6*h2_6_w;
      h2_6_vgs = sl*(zg_vgs);
      h2_6_vgs_w = sl*zgw_vgs + slw*zg_vgs;
      h2_6_vds = sl*(zg_vds);
      h2_6_vds_w = sl*zgw_vds + slw*zg_vds;
      h2_6_T = sl*(zg_T);
      h2_6_T_w = sl*zgw_T + slw*zg_T;
      z = -0.356404172492422 + 0.2146109794252869*h1_1 - 0.4829145157960442*h1_2 + 0.2779668478443868*h1_3 + 0.20656913577844724*h1_4 + 0.021875820921017263*h1_5 - 0.29023407923815053*h1_6 + 0.07311233325515872*h1_7 + 0.8318863866878794*h1_8;
      zw = 0.2146109794252869*h1_1_w - 0.4829145157960442*h1_2_w + 0.2779668478443868*h1_3_w + 0.20656913577844724*h1_4_w + 0.021875820921017263*h1_5_w - 0.29023407923815053*h1_6_w + 0.07311233325515872*h1_7_w + 0.8318863866878794*h1_8_w;
      zg_vgs = 0.2146109794252869*h1_1_vgs - 0.4829145157960442*h1_2_vgs + 0.2779668478443868*h1_3_vgs + 0.20656913577844724*h1_4_vgs + 0.021875820921017263*h1_5_vgs - 0.29023407923815053*h1_6_vgs + 0.07311233325515872*h1_7_vgs + 0.8318863866878794*h1_8_vgs;
      zgw_vgs = 0.2146109794252869*h1_1_vgs_w - 0.4829145157960442*h1_2_vgs_w + 0.2779668478443868*h1_3_vgs_w + 0.20656913577844724*h1_4_vgs_w + 0.021875820921017263*h1_5_vgs_w - 0.29023407923815053*h1_6_vgs_w + 0.07311233325515872*h1_7_vgs_w + 0.8318863866878794*h1_8_vgs_w;
      zg_vds = 0.2146109794252869*h1_1_vds - 0.4829145157960442*h1_2_vds + 0.2779668478443868*h1_3_vds + 0.20656913577844724*h1_4_vds + 0.021875820921017263*h1_5_vds - 0.29023407923815053*h1_6_vds + 0.07311233325515872*h1_7_vds + 0.8318863866878794*h1_8_vds;
      zgw_vds = 0.2146109794252869*h1_1_vds_w - 0.4829145157960442*h1_2_vds_w + 0.2779668478443868*h1_3_vds_w + 0.20656913577844724*h1_4_vds_w + 0.021875820921017263*h1_5_vds_w - 0.29023407923815053*h1_6_vds_w + 0.07311233325515872*h1_7_vds_w + 0.8318863866878794*h1_8_vds_w;
      zg_T = 0.2146109794252869*h1_1_T - 0.4829145157960442*h1_2_T + 0.2779668478443868*h1_3_T + 0.20656913577844724*h1_4_T + 0.021875820921017263*h1_5_T - 0.29023407923815053*h1_6_T + 0.07311233325515872*h1_7_T + 0.8318863866878794*h1_8_T;
      zgw_T = 0.2146109794252869*h1_1_T_w - 0.4829145157960442*h1_2_T_w + 0.2779668478443868*h1_3_T_w + 0.20656913577844724*h1_4_T_w + 0.021875820921017263*h1_5_T_w - 0.29023407923815053*h1_6_T_w + 0.07311233325515872*h1_7_T_w + 0.8318863866878794*h1_8_T_w;
      h2_7 = tanh(z);
      sl = (1.0 - h2_7*h2_7);
      h2_7_w = sl*zw;
      slw = -2.0*h2_7*h2_7_w;
      h2_7_vgs = sl*(zg_vgs);
      h2_7_vgs_w = sl*zgw_vgs + slw*zg_vgs;
      h2_7_vds = sl*(zg_vds);
      h2_7_vds_w = sl*zgw_vds + slw*zg_vds;
      h2_7_T = sl*(zg_T);
      h2_7_T_w = sl*zgw_T + slw*zg_T;
      z = -0.7754826696121152 + 1.2546480013638108*h1_1 - 0.4093932291001875*h1_2 + 0.3646865796231494*h1_3 - 0.05986029451092251*h1_4 + 0.9105778579502084*h1_5 + 0.6082148769376191*h1_6 - 1.4330491895740476*h1_7 + 1.0060032818474456*h1_8;
      zw = 1.2546480013638108*h1_1_w - 0.4093932291001875*h1_2_w + 0.3646865796231494*h1_3_w - 0.05986029451092251*h1_4_w + 0.9105778579502084*h1_5_w + 0.6082148769376191*h1_6_w - 1.4330491895740476*h1_7_w + 1.0060032818474456*h1_8_w;
      zg_vgs = 1.2546480013638108*h1_1_vgs - 0.4093932291001875*h1_2_vgs + 0.3646865796231494*h1_3_vgs - 0.05986029451092251*h1_4_vgs + 0.9105778579502084*h1_5_vgs + 0.6082148769376191*h1_6_vgs - 1.4330491895740476*h1_7_vgs + 1.0060032818474456*h1_8_vgs;
      zgw_vgs = 1.2546480013638108*h1_1_vgs_w - 0.4093932291001875*h1_2_vgs_w + 0.3646865796231494*h1_3_vgs_w - 0.05986029451092251*h1_4_vgs_w + 0.9105778579502084*h1_5_vgs_w + 0.6082148769376191*h1_6_vgs_w - 1.4330491895740476*h1_7_vgs_w + 1.0060032818474456*h1_8_vgs_w;
      zg_vds = 1.2546480013638108*h1_1_vds - 0.4093932291001875*h1_2_vds + 0.3646865796231494*h1_3_vds - 0.05986029451092251*h1_4_vds + 0.9105778579502084*h1_5_vds + 0.6082148769376191*h1_6_vds - 1.4330491895740476*h1_7_vds + 1.0060032818474456*h1_8_vds;
      zgw_vds = 1.2546480013638108*h1_1_vds_w - 0.4093932291001875*h1_2_vds_w + 0.3646865796231494*h1_3_vds_w - 0.05986029451092251*h1_4_vds_w + 0.9105778579502084*h1_5_vds_w + 0.6082148769376191*h1_6_vds_w - 1.4330491895740476*h1_7_vds_w + 1.0060032818474456*h1_8_vds_w;
      zg_T = 1.2546480013638108*h1_1_T - 0.4093932291001875*h1_2_T + 0.3646865796231494*h1_3_T - 0.05986029451092251*h1_4_T + 0.9105778579502084*h1_5_T + 0.6082148769376191*h1_6_T - 1.4330491895740476*h1_7_T + 1.0060032818474456*h1_8_T;
      zgw_T = 1.2546480013638108*h1_1_T_w - 0.4093932291001875*h1_2_T_w + 0.3646865796231494*h1_3_T_w - 0.05986029451092251*h1_4_T_w + 0.9105778579502084*h1_5_T_w + 0.6082148769376191*h1_6_T_w - 1.4330491895740476*h1_7_T_w + 1.0060032818474456*h1_8_T_w;
      h2_8 = tanh(z);
      sl = (1.0 - h2_8*h2_8);
      h2_8_w = sl*zw;
      slw = -2.0*h2_8*h2_8_w;
      h2_8_vgs = sl*(zg_vgs);
      h2_8_vgs_w = sl*zgw_vgs + slw*zg_vgs;
      h2_8_vds = sl*(zg_vds);
      h2_8_vds_w = sl*zgw_vds + slw*zg_vds;
      h2_8_T = sl*(zg_T);
      h2_8_T_w = sl*zgw_T + slw*zg_T;
      // output
      z = -1.3623426036804986 - 0.8479847226899015*h2_1 + 1.6004655041728928*h2_2 - 0.1921282259735084*h2_3 + 1.3521581218362921*h2_4 + 0.6704270182426382*h2_5 - 1.9742163674543047*h2_6 + 0.9231977751685685*h2_7 + 1.2968005030335896*h2_8;
      zw = - 0.8479847226899015*h2_1_w + 1.6004655041728928*h2_2_w - 0.1921282259735084*h2_3_w + 1.3521581218362921*h2_4_w + 0.6704270182426382*h2_5_w - 1.9742163674543047*h2_6_w + 0.9231977751685685*h2_7_w + 1.2968005030335896*h2_8_w;
      zg_vgs = - 0.8479847226899015*h2_1_vgs + 1.6004655041728928*h2_2_vgs - 0.1921282259735084*h2_3_vgs + 1.3521581218362921*h2_4_vgs + 0.6704270182426382*h2_5_vgs - 1.9742163674543047*h2_6_vgs + 0.9231977751685685*h2_7_vgs + 1.2968005030335896*h2_8_vgs;
      zgw_vgs = - 0.8479847226899015*h2_1_vgs_w + 1.6004655041728928*h2_2_vgs_w - 0.1921282259735084*h2_3_vgs_w + 1.3521581218362921*h2_4_vgs_w + 0.6704270182426382*h2_5_vgs_w - 1.9742163674543047*h2_6_vgs_w + 0.9231977751685685*h2_7_vgs_w + 1.2968005030335896*h2_8_vgs_w;
      zg_vds = - 0.8479847226899015*h2_1_vds + 1.6004655041728928*h2_2_vds - 0.1921282259735084*h2_3_vds + 1.3521581218362921*h2_4_vds + 0.6704270182426382*h2_5_vds - 1.9742163674543047*h2_6_vds + 0.9231977751685685*h2_7_vds + 1.2968005030335896*h2_8_vds;
      zgw_vds = - 0.8479847226899015*h2_1_vds_w + 1.6004655041728928*h2_2_vds_w - 0.1921282259735084*h2_3_vds_w + 1.3521581218362921*h2_4_vds_w + 0.6704270182426382*h2_5_vds_w - 1.9742163674543047*h2_6_vds_w + 0.9231977751685685*h2_7_vds_w + 1.2968005030335896*h2_8_vds_w;
      zg_T = - 0.8479847226899015*h2_1_T + 1.6004655041728928*h2_2_T - 0.1921282259735084*h2_3_T + 1.3521581218362921*h2_4_T + 0.6704270182426382*h2_5_T - 1.9742163674543047*h2_6_T + 0.9231977751685685*h2_7_T + 1.2968005030335896*h2_8_T;
      zgw_T = - 0.8479847226899015*h2_1_T_w + 1.6004655041728928*h2_2_T_w - 0.1921282259735084*h2_3_T_w + 1.3521581218362921*h2_4_T_w + 0.6704270182426382*h2_5_T_w - 1.9742163674543047*h2_6_T_w + 0.9231977751685685*h2_7_T_w + 1.2968005030335896*h2_8_T_w;
      u = z;
      u_w = zw;
      u_vgs = zg_vgs;
      u_vgs_w = zgw_vgs;
      u_vds = zg_vds;
      u_vds_w = zgw_vds;
      u_T = zg_T;
      u_T_w = zgw_T;
      fh_Qg = 0.0 + 4.0013788575836924e-13*u;
      d_vgs = 4.0013788575836924e-13*u_vgs;
      hw_vgs = 4.0013788575836924e-13*u_vgs_w;
      d_vds = 4.0013788575836924e-13*u_vds;
      hw_vds = 4.0013788575836924e-13*u_vds_w;
      d_T = 4.0013788575836924e-13*u_T;
      hw_T = 4.0013788575836924e-13*u_T_w;
    end
  endfunction

  // Core.Constituents.Qg.Network continued outside its domain, with the continuation's exact gradient
  analog function real xg_Qg;
    input vgs, vds, T;
    output d_vgs, d_vds, d_T;
    real vgs, vds, T;
    real d_vgs, d_vds, d_T;
    real u_vgs, u_vds, u_T, b_vgs, b_vds, b_T, p_vgs, p_vds, p_T, g_vgs, g_vds, g_T;
    real w_vgs, w_vds, w_T, h_vgs, h_vds, h_T, q_vgs, q_vds, q_T, j_vgs, j_vds, j_T;
    real jgg, jgd, jdd, ex, ey, bx, by, t, cx, cy, e, best;
    real cr, fb, s, dist2, dist, k0, ds, o_vgs, o_vds, o_T, y_vgs, y_vds;
    real y_T, gl, ga, fo, cg;
    integer inside, inbox, onedge, interior;
    begin
      // normalised by the domain's centre and extent
      u_vgs = (vgs - (-0.9208796670951123))/2.1582407449889756;
      u_vds = (vds - 7.566235437630191)/14.867529124463616;
      u_T = (T - 64.251518025185)/78.50303605037001;
      inbox = 1;
      // Domain.Box.T: the Jacobian is one inside the interval, zero where clamped
      j_T = 0.0;
      if (u_T < (-0.5)) begin b_T = (-0.5); inbox = 0; end
      else if (u_T > 0.5) begin b_T = 0.5; inbox = 0; end
      else begin b_T = u_T; j_T = 1.0; end
      // Domain.Polygon: 10 vertices, counter-clockwise
      inside = 1;
      cr = 0.9945485555180813*(u_vds - (-0.47527975047364995)) - (-0.024720249526350158)*(u_vgs - (-0.5));
      if (cr < 0.0) inside = 0;
      cr = 0.005451444481918644*(u_vds - (-0.5000000000000001)) - 0.0018944617201674951*(u_vgs - 0.49454855551808136);
      if (cr < 0.0) inside = 0;
      cr = (-0.09398705129148938)*(u_vds - (-0.4981055382798326)) - 0.9426177824000829*(u_vgs - 0.5);
      if (cr < 0.0) inside = 0;
      cr = (-0.09249964651191961)*(u_vds - 0.44451224412025026) - 0.016160326304840433*(u_vgs - 0.4060129487085106);
      if (cr < 0.0) inside = 0;
      cr = (-0.13091432540818732)*(u_vds - 0.4606725704250907) - 0.01891242532930726*(u_vgs - 0.313513302196591);
      if (cr < 0.0) inside = 0;
      cr = (-0.14509413109986158)*(u_vds - 0.47958499575439795) - 0.013984722374358438*(u_vgs - 0.1825989767884037);
      if (cr < 0.0) inside = 0;
      cr = (-0.16824602428679386)*(u_vds - 0.4935697181287564) - 0.005939079510797307*(u_vgs - 0.037504845688542135);
      if (cr < 0.0) inside = 0;
      cr = (-0.18393634886175214)*(u_vds - 0.4995087976395537) - 0.00048644775735068313*(u_vgs - (-0.13074117859825174));
      if (cr < 0.0) inside = 0;
      cr = (-0.1853224541917186)*(u_vds - 0.4999952453969044) - 4.754603095624699e-06*(u_vgs - (-0.3146775274600039));
      if (cr < 0.0) inside = 0;
      cr = (-1.834827750846202e-08)*(u_vds - 0.5) - (-0.9752797504736499)*(u_vgs - (-0.4999999816517225));
      if (cr < 0.0) inside = 0;
      if (inside) begin
        b_vgs = u_vgs;
        b_vds = u_vds;
        jgg = 1.0; jgd = 0.0; jdd = 1.0;
      end else begin
        onedge = 0; ex = 0.0; ey = 0.0;
        t = ((u_vgs - (-0.5))*0.9945485555180813 + (u_vds - (-0.47527975047364995))*(-0.024720249526350158))/0.989737920019747;
        interior = (t > 0.0 && t < 1.0) ? 1 : 0;
        if (t < 0.0) t = 0.0; else if (t > 1.0) t = 1.0;
        cx = (-0.5) + t*0.9945485555180813;
        cy = (-0.47527975047364995) + t*(-0.024720249526350158);
        e = (u_vgs - cx)*(u_vgs - cx) + (u_vds - cy)*(u_vds - cy);
        best = e; bx = cx; by = cy; onedge = interior; ex = 0.9996912389232716; ey = (-0.024848074775611215);
        t = ((u_vgs - 0.49454855551808136)*0.005451444481918644 + (u_vds - (-0.5000000000000001))*0.0018944617201674951)/3.3307232148621213e-05;
        interior = (t > 0.0 && t < 1.0) ? 1 : 0;
        if (t < 0.0) t = 0.0; else if (t > 1.0) t = 1.0;
        cx = 0.49454855551808136 + t*0.005451444481918644;
        cy = (-0.5000000000000001) + t*0.0018944617201674951;
        e = (u_vgs - cx)*(u_vgs - cx) + (u_vds - cy)*(u_vds - cy);
        if (e < best) begin best = e; bx = cx; by = cy; onedge = interior; ex = 0.9445877770575726; ey = 0.32825893960931757; end
        t = ((u_vgs - 0.5)*(-0.09398705129148938) + (u_vds - (-0.4981055382798326))*0.9426177824000829)/0.897361849507319;
        interior = (t > 0.0 && t < 1.0) ? 1 : 0;
        if (t < 0.0) t = 0.0; else if (t > 1.0) t = 1.0;
        cx = 0.5 + t*(-0.09398705129148938);
        cy = (-0.4981055382798326) + t*0.9426177824000829;
        e = (u_vgs - cx)*(u_vgs - cx) + (u_vds - cy)*(u_vds - cy);
        if (e < best) begin best = e; bx = cx; by = cy; onedge = interior; ex = (-0.09921657329673422); ey = 0.9950658629373503; end
        t = ((u_vgs - 0.4060129487085106)*(-0.09249964651191961) + (u_vds - 0.44451224412025026)*0.016160326304840433)/0.008817340751109;
        interior = (t > 0.0 && t < 1.0) ? 1 : 0;
        if (t < 0.0) t = 0.0; else if (t > 1.0) t = 1.0;
        cx = 0.4060129487085106 + t*(-0.09249964651191961);
        cy = 0.44451224412025026 + t*0.016160326304840433;
        e = (u_vgs - cx)*(u_vgs - cx) + (u_vds - cy)*(u_vds - cy);
        if (e < best) begin best = e; bx = cx; by = cy; onedge = interior; ex = (-0.9850794534316982); ey = 0.17210017555687354; end
        t = ((u_vgs - 0.313513302196591)*(-0.13091432540818732) + (u_vds - 0.4606725704250907)*0.01891242532930726)/0.017496240428917384;
        interior = (t > 0.0 && t < 1.0) ? 1 : 0;
        if (t < 0.0) t = 0.0; else if (t > 1.0) t = 1.0;
        cx = 0.313513302196591 + t*(-0.13091432540818732);
        cy = 0.4606725704250907 + t*0.01891242532930726;
        e = (u_vgs - cx)*(u_vgs - cx) + (u_vds - cy)*(u_vds - cy);
        if (e < best) begin best = e; bx = cx; by = cy; onedge = interior; ex = (-0.9897255986340473); ey = 0.14297985665287416; end
        t = ((u_vgs - 0.1825989767884037)*(-0.14509413109986158) + (u_vds - 0.47958499575439795)*0.013984722374358438)/0.0212478793395117;
        interior = (t > 0.0 && t < 1.0) ? 1 : 0;
        if (t < 0.0) t = 0.0; else if (t > 1.0) t = 1.0;
        cx = 0.1825989767884037 + t*(-0.14509413109986158);
        cy = 0.47958499575439795 + t*0.013984722374358438;
        e = (u_vgs - cx)*(u_vgs - cx) + (u_vds - cy)*(u_vds - cy);
        if (e < best) begin best = e; bx = cx; by = cy; onedge = interior; ex = (-0.9953871968082156); ey = 0.09593919131555459; end
        t = ((u_vgs - 0.037504845688542135)*(-0.16824602428679386) + (u_vds - 0.4935697181287564)*0.005939079510797307)/0.028341997353748004;
        interior = (t > 0.0 && t < 1.0) ? 1 : 0;
        if (t < 0.0) t = 0.0; else if (t > 1.0) t = 1.0;
        cx = 0.037504845688542135 + t*(-0.16824602428679386);
        cy = 0.4935697181287564 + t*0.005939079510797307;
        e = (u_vgs - cx)*(u_vgs - cx) + (u_vds - cy)*(u_vds - cy);
        if (e < best) begin best = e; bx = cx; by = cy; onedge = interior; ex = (-0.9993775377514109); ey = 0.03527799651237496; end
        t = ((u_vgs - (-0.13074117859825174))*(-0.18393634886175214) + (u_vds - 0.4995087976395537)*0.00048644775735068313)/0.03383281706401282;
        interior = (t > 0.0 && t < 1.0) ? 1 : 0;
        if (t < 0.0) t = 0.0; else if (t > 1.0) t = 1.0;
        cx = (-0.13074117859825174) + t*(-0.18393634886175214);
        cy = 0.4995087976395537 + t*0.00048644775735068313;
        e = (u_vgs - cx)*(u_vgs - cx) + (u_vds - cy)*(u_vds - cy);
        if (e < best) begin best = e; bx = cx; by = cy; onedge = interior; ex = (-0.9999965029244544); ey = 0.0026446434281010055; end
        t = ((u_vgs - (-0.3146775274600039))*(-0.1853224541917186) + (u_vds - 0.4999952453969044)*4.754603095624699e-06)/0.034344412050247894;
        interior = (t > 0.0 && t < 1.0) ? 1 : 0;
        if (t < 0.0) t = 0.0; else if (t > 1.0) t = 1.0;
        cx = (-0.3146775274600039) + t*(-0.1853224541917186);
        cy = 0.4999952453969044 + t*4.754603095624699e-06;
        e = (u_vgs - cx)*(u_vgs - cx) + (u_vds - cy)*(u_vds - cy);
        if (e < best) begin best = e; bx = cx; by = cy; onedge = interior; ex = (-0.999999999670889); ey = 2.5655839249469495e-05; end
        t = ((u_vgs - (-0.4999999816517225))*(-1.834827750846202e-08) + (u_vds - 0.5)*(-0.9752797504736499))/0.9511705916839451;
        interior = (t > 0.0 && t < 1.0) ? 1 : 0;
        if (t < 0.0) t = 0.0; else if (t > 1.0) t = 1.0;
        cx = (-0.4999999816517225) + t*(-1.834827750846202e-08);
        cy = 0.5 + t*(-0.9752797504736499);
        e = (u_vgs - cx)*(u_vgs - cx) + (u_vds - cy)*(u_vds - cy);
        if (e < best) begin best = e; bx = cx; by = cy; onedge = interior; ex = (-1.881334816964166e-08); ey = (-0.9999999999999999); end
        b_vgs = bx;
        b_vds = by;
        if (onedge) begin jgg = ex*ex; jgd = ex*ey; jdd = ey*ey; end
        else begin jgg = 0.0; jgd = 0.0; jdd = 0.0; end
      end
      if (inside && inbox) begin
        xg_Qg = f_Qg(vgs, vds, T, d_vgs, d_vds, d_T);
      end else begin
        p_vgs = (-0.9208796670951123) + 2.1582407449889756*b_vgs;
        p_vds = 7.566235437630191 + 14.867529124463616*b_vds;
        p_T = 64.251518025185 + 78.50303605037001*b_T;
        dist2 = 0.0;
        w_vgs = vgs - p_vgs;
        dist2 = dist2 + (u_vgs - b_vgs)*(u_vgs - b_vgs);
        w_vds = vds - p_vds;
        dist2 = dist2 + (u_vds - b_vds)*(u_vds - b_vds);
        w_T = T - p_T;
        dist2 = dist2 + (u_T - b_T)*(u_T - b_T);
        dist = sqrt(dist2);
        fb = fh_Qg(p_vgs, p_vds, p_T, w_vgs, w_vds, w_T, g_vgs, g_vds, g_T, h_vgs, h_vds, h_T);
        xg_Qg = fb;
        xg_Qg = xg_Qg + g_vgs*w_vgs;
        xg_Qg = xg_Qg + g_vds*w_vds;
        xg_Qg = xg_Qg + g_T*w_T;
        q_vgs = 2.1582407449889756*g_vgs + jgg*2.1582407449889756*h_vgs + jgd*14.867529124463616*h_vds;
        q_vds = 14.867529124463616*g_vds + jgd*2.1582407449889756*h_vgs + jdd*14.867529124463616*h_vds;
        q_T = 78.50303605037001*g_T + j_T*78.50303605037001*h_T;
        d_vgs = q_vgs/2.1582407449889756;
        d_vds = q_vds/14.867529124463616;
        d_T = q_T/78.50303605037001;
      end
    end
  endfunction

  // Core.Constituents.Qd.Network with its Hessian along a direction
  analog function real fh_Qd;
    input vgs, vds, T, w_vgs, w_vds, w_T;
    output d_vgs, d_vds, d_T, hw_vgs, hw_vds, hw_T;
    real vgs, vds, T, w_vgs, w_vds, w_T;
    real d_vgs, d_vds, d_T, hw_vgs, hw_vds, hw_T;
    real z, zw, sl, slw, zg_vgs, zgw_vgs, zg_vds, zgw_vds, zg_T, zgw_T, x1, x1_w;
    real x2, x2_w, x3, x3_w, h1_1, h1_1_w, h1_1_vgs, h1_1_vgs_w, h1_1_vds, h1_1_vds_w, h1_1_T, h1_1_T_w;
    real h1_2, h1_2_w, h1_2_vgs, h1_2_vgs_w, h1_2_vds, h1_2_vds_w, h1_2_T, h1_2_T_w, h1_3, h1_3_w, h1_3_vgs, h1_3_vgs_w;
    real h1_3_vds, h1_3_vds_w, h1_3_T, h1_3_T_w, h1_4, h1_4_w, h1_4_vgs, h1_4_vgs_w, h1_4_vds, h1_4_vds_w, h1_4_T, h1_4_T_w;
    real h1_5, h1_5_w, h1_5_vgs, h1_5_vgs_w, h1_5_vds, h1_5_vds_w, h1_5_T, h1_5_T_w, h1_6, h1_6_w, h1_6_vgs, h1_6_vgs_w;
    real h1_6_vds, h1_6_vds_w, h1_6_T, h1_6_T_w, h1_7, h1_7_w, h1_7_vgs, h1_7_vgs_w, h1_7_vds, h1_7_vds_w, h1_7_T, h1_7_T_w;
    real h1_8, h1_8_w, h1_8_vgs, h1_8_vgs_w, h1_8_vds, h1_8_vds_w, h1_8_T, h1_8_T_w, h2_1, h2_1_w, h2_1_vgs, h2_1_vgs_w;
    real h2_1_vds, h2_1_vds_w, h2_1_T, h2_1_T_w, h2_2, h2_2_w, h2_2_vgs, h2_2_vgs_w, h2_2_vds, h2_2_vds_w, h2_2_T, h2_2_T_w;
    real h2_3, h2_3_w, h2_3_vgs, h2_3_vgs_w, h2_3_vds, h2_3_vds_w, h2_3_T, h2_3_T_w, h2_4, h2_4_w, h2_4_vgs, h2_4_vgs_w;
    real h2_4_vds, h2_4_vds_w, h2_4_T, h2_4_T_w, h2_5, h2_5_w, h2_5_vgs, h2_5_vgs_w, h2_5_vds, h2_5_vds_w, h2_5_T, h2_5_T_w;
    real h2_6, h2_6_w, h2_6_vgs, h2_6_vgs_w, h2_6_vds, h2_6_vds_w, h2_6_T, h2_6_T_w, h2_7, h2_7_w, h2_7_vgs, h2_7_vgs_w;
    real h2_7_vds, h2_7_vds_w, h2_7_T, h2_7_T_w, h2_8, h2_8_w, h2_8_vgs, h2_8_vgs_w, h2_8_vds, h2_8_vds_w, h2_8_T, h2_8_T_w;
    real u, u_w, u_vgs, u_vgs_w, u_vds, u_vds_w, u_T, u_T_w;
    begin
      x1 = (vgs - (-0.9208796670951123))*0.9266806794578499;
      x1_w = w_vgs*0.9266806794578499;
      x2 = (vds - 7.566235437630191)*0.13452134401466356;
      x2_w = w_vds*0.13452134401466356;
      x3 = (T - 64.251518025185)*0.025476721673754595;
      x3_w = w_T*0.025476721673754595;
      // hidden layer 1
      z = -0.4409039123793923 - 0.011381735093289005*x1 + 0.6368703371649228*x2 + 0.0037664386438230153*x3;
      zw = - 0.011381735093289005*x1_w + 0.6368703371649228*x2_w + 0.0037664386438230153*x3_w;
      zg_vgs = -0.01054723400965831;
      zgw_vgs = 0.0;
      zg_vds = 0.08567265371849736;
      zgw_vds = 0.0;
      zg_T = 9.595650902995267e-05;
      zgw_T = 0.0;
      h1_1 = tanh(z);
      sl = (1.0 - h1_1*h1_1);
      h1_1_w = sl*zw;
      slw = -2.0*h1_1*h1_1_w;
      h1_1_vgs = sl*(zg_vgs);
      h1_1_vgs_w = sl*zgw_vgs + slw*zg_vgs;
      h1_1_vds = sl*(zg_vds);
      h1_1_vds_w = sl*zgw_vds + slw*zg_vds;
      h1_1_T = sl*(zg_T);
      h1_1_T_w = sl*zgw_T + slw*zg_T;
      z = 2.45825413115937 + 0.018837219766566105*x1 + 2.4980173852902707*x2 - 0.014898284596705426*x3;
      zw = 0.018837219766566105*x1_w + 2.4980173852902707*x2_w - 0.014898284596705426*x3_w;
      zg_vgs = 0.01745608761237832;
      zgw_vgs = 0.0;
      zg_vds = 0.3360366560412429;
      zgw_vds = 0.0;
      zg_T = -0.00037955945008664934;
      zgw_T = 0.0;
      h1_2 = tanh(z);
      sl = (1.0 - h1_2*h1_2);
      h1_2_w = sl*zw;
      slw = -2.0*h1_2*h1_2_w;
      h1_2_vgs = sl*(zg_vgs);
      h1_2_vgs_w = sl*zgw_vgs + slw*zg_vgs;
      h1_2_vds = sl*(zg_vds);
      h1_2_vds_w = sl*zgw_vds + slw*zg_vds;
      h1_2_T = sl*(zg_T);
      h1_2_T_w = sl*zgw_T + slw*zg_T;
      z = -0.0391861826632896 + 0.009358366494330137*x1 - 0.11764553360375875*x2 - 0.08788085156397929*x3;
      zw = 0.009358366494330137*x1_w - 0.11764553360375875*x2_w - 0.08788085156397929*x3_w;
      zg_vgs = 0.008672217421581429;
      zgw_vgs = 0.0;
      zg_vds = -0.015825835297699892;
      zgw_vds = 0.0;
      zg_T = -0.0022389159957480415;
      zgw_T = 0.0;
      h1_3 = tanh(z);
      sl = (1.0 - h1_3*h1_3);
      h1_3_w = sl*zw;
      slw = -2.0*h1_3*h1_3_w;
      h1_3_vgs = sl*(zg_vgs);
      h1_3_vgs_w = sl*zgw_vgs + slw*zg_vgs;
      h1_3_vds = sl*(zg_vds);
      h1_3_vds_w = sl*zgw_vds + slw*zg_vds;
      h1_3_T = sl*(zg_T);
      h1_3_T_w = sl*zgw_T + slw*zg_T;
      z = 0.586398055324918 - 0.0123009168204501*x1 + 0.6833252082934453*x2 - 0.037651615823980855*x3;
      zw = - 0.0123009168204501*x1_w + 0.6833252082934453*x2_w - 0.037651615823980855*x3_w;
      zg_vgs = -0.011399021957129194;
      zgw_vgs = 0.0;
      zg_vds = 0.0919218254187342;
      zgw_vds = 0.0;
      zg_T = -0.0009592397369146945;
      zgw_T = 0.0;
      h1_4 = tanh(z);
      sl = (1.0 - h1_4*h1_4);
      h1_4_w = sl*zw;
      slw = -2.0*h1_4*h1_4_w;
      h1_4_vgs = sl*(zg_vgs);
      h1_4_vgs_w = sl*zgw_vgs + slw*zg_vgs;
      h1_4_vds = sl*(zg_vds);
      h1_4_vds_w = sl*zgw_vds + slw*zg_vds;
      h1_4_T = sl*(zg_T);
      h1_4_T_w = sl*zgw_T + slw*zg_T;
      z = 0.46986978195048584 - 0.03315303952346632*x1 + 0.5339778745104701*x2 + 0.11866430743094514*x3;
      zw = - 0.03315303952346632*x1_w + 0.5339778745104701*x2_w + 0.11866430743094514*x3_w;
      zg_vgs = -0.030722281191698723;
      zgw_vgs = 0.0;
      zg_vds = 0.07183142135324179;
      zgw_vds = 0.0;
      zg_T = 0.0030231775330270385;
      zgw_T = 0.0;
      h1_5 = tanh(z);
      sl = (1.0 - h1_5*h1_5);
      h1_5_w = sl*zw;
      slw = -2.0*h1_5*h1_5_w;
      h1_5_vgs = sl*(zg_vgs);
      h1_5_vgs_w = sl*zgw_vgs + slw*zg_vgs;
      h1_5_vds = sl*(zg_vds);
      h1_5_vds_w = sl*zgw_vds + slw*zg_vds;
      h1_5_T = sl*(zg_T);
      h1_5_T_w = sl*zgw_T + slw*zg_T;
      z = 1.0500540649041596 - 0.024413259463041913*x1 - 0.18558672527173922*x2 + 0.0598309694858573*x3;
      zw = - 0.024413259463041913*x1_w - 0.18558672527173922*x2_w + 0.0598309694858573*x3_w;
      zg_vgs = -0.022623295866992466;
      zgw_vgs = 0.0;
      zg_vds = -0.024965375714834488;
      zgw_vds = 0.0;
      zg_T = 0.0015242969570620905;
      zgw_T = 0.0;
      h1_6 = tanh(z);
      sl = (1.0 - h1_6*h1_6);
      h1_6_w = sl*zw;
      slw = -2.0*h1_6*h1_6_w;
      h1_6_vgs = sl*(zg_vgs);
      h1_6_vgs_w = sl*zgw_vgs + slw*zg_vgs;
      h1_6_vds = sl*(zg_vds);
      h1_6_vds_w = sl*zgw_vds + slw*zg_vds;
      h1_6_T = sl*(zg_T);
      h1_6_T_w = sl*zgw_T + slw*zg_T;
      z = -2.1611430808380647 + 0.05572018825698978*x1 - 1.2062194707756406*x2 + 0.0009517227456368826*x3;
      zw = 0.05572018825698978*x1_w - 1.2062194707756406*x2_w + 0.0009517227456368826*x3_w;
      zg_vgs = 0.0516348219135066;
      zgw_vgs = 0.0;
      zg_vds = -0.16226226438539537;
      zgw_vds = 0.0;
      zg_T = 2.4246775501172398e-05;
      zgw_T = 0.0;
      h1_7 = tanh(z);
      sl = (1.0 - h1_7*h1_7);
      h1_7_w = sl*zw;
      slw = -2.0*h1_7*h1_7_w;
      h1_7_vgs = sl*(zg_vgs);
      h1_7_vgs_w = sl*zgw_vgs + slw*zg_vgs;
      h1_7_vds = sl*(zg_vds);
      h1_7_vds_w = sl*zgw_vds + slw*zg_vds;
      h1_7_T = sl*(zg_T);
      h1_7_T_w = sl*zgw_T + slw*zg_T;
      z = 0.5265128012773911 + 0.0004133483455408087*x1 + 0.36145996966153005*x2 - 0.0038253004541466237*x3;
      zw = 0.0004133483455408087*x1_w + 0.36145996966153005*x2_w - 0.0038253004541466237*x3_w;
      zg_vgs = 0.00038304192569853473;
      zgw_vgs = 0.0;
      zg_vds = 0.04862408092636854;
      zgw_vds = 0.0;
      zg_T = -9.745611498878058e-05;
      zgw_T = 0.0;
      h1_8 = tanh(z);
      sl = (1.0 - h1_8*h1_8);
      h1_8_w = sl*zw;
      slw = -2.0*h1_8*h1_8_w;
      h1_8_vgs = sl*(zg_vgs);
      h1_8_vgs_w = sl*zgw_vgs + slw*zg_vgs;
      h1_8_vds = sl*(zg_vds);
      h1_8_vds_w = sl*zgw_vds + slw*zg_vds;
      h1_8_T = sl*(zg_T);
      h1_8_T_w = sl*zgw_T + slw*zg_T;
      // hidden layer 2
      z = 0.15155581445562585 + 0.3551435597808497*h1_1 + 0.4210214174303734*h1_2 + 0.04936187585299919*h1_3 + 0.2730608083120263*h1_4 - 0.26471984308178365*h1_5 + 0.6463115447967194*h1_6 + 0.09466816045982983*h1_7 + 0.07383277218182761*h1_8;
      zw = 0.3551435597808497*h1_1_w + 0.4210214174303734*h1_2_w + 0.04936187585299919*h1_3_w + 0.2730608083120263*h1_4_w - 0.26471984308178365*h1_5_w + 0.6463115447967194*h1_6_w + 0.09466816045982983*h1_7_w + 0.07383277218182761*h1_8_w;
      zg_vgs = 0.3551435597808497*h1_1_vgs + 0.4210214174303734*h1_2_vgs + 0.04936187585299919*h1_3_vgs + 0.2730608083120263*h1_4_vgs - 0.26471984308178365*h1_5_vgs + 0.6463115447967194*h1_6_vgs + 0.09466816045982983*h1_7_vgs + 0.07383277218182761*h1_8_vgs;
      zgw_vgs = 0.3551435597808497*h1_1_vgs_w + 0.4210214174303734*h1_2_vgs_w + 0.04936187585299919*h1_3_vgs_w + 0.2730608083120263*h1_4_vgs_w - 0.26471984308178365*h1_5_vgs_w + 0.6463115447967194*h1_6_vgs_w + 0.09466816045982983*h1_7_vgs_w + 0.07383277218182761*h1_8_vgs_w;
      zg_vds = 0.3551435597808497*h1_1_vds + 0.4210214174303734*h1_2_vds + 0.04936187585299919*h1_3_vds + 0.2730608083120263*h1_4_vds - 0.26471984308178365*h1_5_vds + 0.6463115447967194*h1_6_vds + 0.09466816045982983*h1_7_vds + 0.07383277218182761*h1_8_vds;
      zgw_vds = 0.3551435597808497*h1_1_vds_w + 0.4210214174303734*h1_2_vds_w + 0.04936187585299919*h1_3_vds_w + 0.2730608083120263*h1_4_vds_w - 0.26471984308178365*h1_5_vds_w + 0.6463115447967194*h1_6_vds_w + 0.09466816045982983*h1_7_vds_w + 0.07383277218182761*h1_8_vds_w;
      zg_T = 0.3551435597808497*h1_1_T + 0.4210214174303734*h1_2_T + 0.04936187585299919*h1_3_T + 0.2730608083120263*h1_4_T - 0.26471984308178365*h1_5_T + 0.6463115447967194*h1_6_T + 0.09466816045982983*h1_7_T + 0.07383277218182761*h1_8_T;
      zgw_T = 0.3551435597808497*h1_1_T_w + 0.4210214174303734*h1_2_T_w + 0.04936187585299919*h1_3_T_w + 0.2730608083120263*h1_4_T_w - 0.26471984308178365*h1_5_T_w + 0.6463115447967194*h1_6_T_w + 0.09466816045982983*h1_7_T_w + 0.07383277218182761*h1_8_T_w;
      h2_1 = tanh(z);
      sl = (1.0 - h2_1*h2_1);
      h2_1_w = sl*zw;
      slw = -2.0*h2_1*h2_1_w;
      h2_1_vgs = sl*(zg_vgs);
      h2_1_vgs_w = sl*zgw_vgs + slw*zg_vgs;
      h2_1_vds = sl*(zg_vds);
      h2_1_vds_w = sl*zgw_vds + slw*zg_vds;
      h2_1_T = sl*(zg_T);
      h2_1_T_w = sl*zgw_T + slw*zg_T;
      z = 0.43322649023084475 + 0.20449267801717255*h1_1 - 0.8062926109844439*h1_2 + 0.18908138177085065*h1_3 - 0.7237719115158205*h1_4 - 0.40982017743037247*h1_5 + 0.05401972836878898*h1_6 + 0.4030212223059671*h1_7 - 0.45539985459518856*h1_8;
      zw = 0.20449267801717255*h1_1_w - 0.8062926109844439*h1_2_w + 0.18908138177085065*h1_3_w - 0.7237719115158205*h1_4_w - 0.40982017743037247*h1_5_w + 0.05401972836878898*h1_6_w + 0.4030212223059671*h1_7_w - 0.45539985459518856*h1_8_w;
      zg_vgs = 0.20449267801717255*h1_1_vgs - 0.8062926109844439*h1_2_vgs + 0.18908138177085065*h1_3_vgs - 0.7237719115158205*h1_4_vgs - 0.40982017743037247*h1_5_vgs + 0.05401972836878898*h1_6_vgs + 0.4030212223059671*h1_7_vgs - 0.45539985459518856*h1_8_vgs;
      zgw_vgs = 0.20449267801717255*h1_1_vgs_w - 0.8062926109844439*h1_2_vgs_w + 0.18908138177085065*h1_3_vgs_w - 0.7237719115158205*h1_4_vgs_w - 0.40982017743037247*h1_5_vgs_w + 0.05401972836878898*h1_6_vgs_w + 0.4030212223059671*h1_7_vgs_w - 0.45539985459518856*h1_8_vgs_w;
      zg_vds = 0.20449267801717255*h1_1_vds - 0.8062926109844439*h1_2_vds + 0.18908138177085065*h1_3_vds - 0.7237719115158205*h1_4_vds - 0.40982017743037247*h1_5_vds + 0.05401972836878898*h1_6_vds + 0.4030212223059671*h1_7_vds - 0.45539985459518856*h1_8_vds;
      zgw_vds = 0.20449267801717255*h1_1_vds_w - 0.8062926109844439*h1_2_vds_w + 0.18908138177085065*h1_3_vds_w - 0.7237719115158205*h1_4_vds_w - 0.40982017743037247*h1_5_vds_w + 0.05401972836878898*h1_6_vds_w + 0.4030212223059671*h1_7_vds_w - 0.45539985459518856*h1_8_vds_w;
      zg_T = 0.20449267801717255*h1_1_T - 0.8062926109844439*h1_2_T + 0.18908138177085065*h1_3_T - 0.7237719115158205*h1_4_T - 0.40982017743037247*h1_5_T + 0.05401972836878898*h1_6_T + 0.4030212223059671*h1_7_T - 0.45539985459518856*h1_8_T;
      zgw_T = 0.20449267801717255*h1_1_T_w - 0.8062926109844439*h1_2_T_w + 0.18908138177085065*h1_3_T_w - 0.7237719115158205*h1_4_T_w - 0.40982017743037247*h1_5_T_w + 0.05401972836878898*h1_6_T_w + 0.4030212223059671*h1_7_T_w - 0.45539985459518856*h1_8_T_w;
      h2_2 = tanh(z);
      sl = (1.0 - h2_2*h2_2);
      h2_2_w = sl*zw;
      slw = -2.0*h2_2*h2_2_w;
      h2_2_vgs = sl*(zg_vgs);
      h2_2_vgs_w = sl*zgw_vgs + slw*zg_vgs;
      h2_2_vds = sl*(zg_vds);
      h2_2_vds_w = sl*zgw_vds + slw*zg_vds;
      h2_2_T = sl*(zg_T);
      h2_2_T_w = sl*zgw_T + slw*zg_T;
      z = 0.02444827051358861 - 0.10998629642425015*h1_1 - 0.16139150163969151*h1_2 - 0.34862033800707254*h1_3 - 0.4969577152816076*h1_4 - 0.29426109358321484*h1_5 - 0.10314400022418588*h1_6 - 0.2167842885832443*h1_7 - 0.6957712289171193*h1_8;
      zw = - 0.10998629642425015*h1_1_w - 0.16139150163969151*h1_2_w - 0.34862033800707254*h1_3_w - 0.4969577152816076*h1_4_w - 0.29426109358321484*h1_5_w - 0.10314400022418588*h1_6_w - 0.2167842885832443*h1_7_w - 0.6957712289171193*h1_8_w;
      zg_vgs = - 0.10998629642425015*h1_1_vgs - 0.16139150163969151*h1_2_vgs - 0.34862033800707254*h1_3_vgs - 0.4969577152816076*h1_4_vgs - 0.29426109358321484*h1_5_vgs - 0.10314400022418588*h1_6_vgs - 0.2167842885832443*h1_7_vgs - 0.6957712289171193*h1_8_vgs;
      zgw_vgs = - 0.10998629642425015*h1_1_vgs_w - 0.16139150163969151*h1_2_vgs_w - 0.34862033800707254*h1_3_vgs_w - 0.4969577152816076*h1_4_vgs_w - 0.29426109358321484*h1_5_vgs_w - 0.10314400022418588*h1_6_vgs_w - 0.2167842885832443*h1_7_vgs_w - 0.6957712289171193*h1_8_vgs_w;
      zg_vds = - 0.10998629642425015*h1_1_vds - 0.16139150163969151*h1_2_vds - 0.34862033800707254*h1_3_vds - 0.4969577152816076*h1_4_vds - 0.29426109358321484*h1_5_vds - 0.10314400022418588*h1_6_vds - 0.2167842885832443*h1_7_vds - 0.6957712289171193*h1_8_vds;
      zgw_vds = - 0.10998629642425015*h1_1_vds_w - 0.16139150163969151*h1_2_vds_w - 0.34862033800707254*h1_3_vds_w - 0.4969577152816076*h1_4_vds_w - 0.29426109358321484*h1_5_vds_w - 0.10314400022418588*h1_6_vds_w - 0.2167842885832443*h1_7_vds_w - 0.6957712289171193*h1_8_vds_w;
      zg_T = - 0.10998629642425015*h1_1_T - 0.16139150163969151*h1_2_T - 0.34862033800707254*h1_3_T - 0.4969577152816076*h1_4_T - 0.29426109358321484*h1_5_T - 0.10314400022418588*h1_6_T - 0.2167842885832443*h1_7_T - 0.6957712289171193*h1_8_T;
      zgw_T = - 0.10998629642425015*h1_1_T_w - 0.16139150163969151*h1_2_T_w - 0.34862033800707254*h1_3_T_w - 0.4969577152816076*h1_4_T_w - 0.29426109358321484*h1_5_T_w - 0.10314400022418588*h1_6_T_w - 0.2167842885832443*h1_7_T_w - 0.6957712289171193*h1_8_T_w;
      h2_3 = tanh(z);
      sl = (1.0 - h2_3*h2_3);
      h2_3_w = sl*zw;
      slw = -2.0*h2_3*h2_3_w;
      h2_3_vgs = sl*(zg_vgs);
      h2_3_vgs_w = sl*zgw_vgs + slw*zg_vgs;
      h2_3_vds = sl*(zg_vds);
      h2_3_vds_w = sl*zgw_vds + slw*zg_vds;
      h2_3_T = sl*(zg_T);
      h2_3_T_w = sl*zgw_T + slw*zg_T;
      z = 0.42223377015104085 + 0.31587620448934833*h1_1 + 0.652334968582689*h1_2 - 0.011015941304574443*h1_3 - 0.5749935909331874*h1_4 + 0.18477326374126474*h1_5 - 0.2156145060046444*h1_6 - 0.5397755313903257*h1_7 + 1.0429463084973176*h1_8;
      zw = 0.31587620448934833*h1_1_w + 0.652334968582689*h1_2_w - 0.011015941304574443*h1_3_w - 0.5749935909331874*h1_4_w + 0.18477326374126474*h1_5_w - 0.2156145060046444*h1_6_w - 0.5397755313903257*h1_7_w + 1.0429463084973176*h1_8_w;
      zg_vgs = 0.31587620448934833*h1_1_vgs + 0.652334968582689*h1_2_vgs - 0.011015941304574443*h1_3_vgs - 0.5749935909331874*h1_4_vgs + 0.18477326374126474*h1_5_vgs - 0.2156145060046444*h1_6_vgs - 0.5397755313903257*h1_7_vgs + 1.0429463084973176*h1_8_vgs;
      zgw_vgs = 0.31587620448934833*h1_1_vgs_w + 0.652334968582689*h1_2_vgs_w - 0.011015941304574443*h1_3_vgs_w - 0.5749935909331874*h1_4_vgs_w + 0.18477326374126474*h1_5_vgs_w - 0.2156145060046444*h1_6_vgs_w - 0.5397755313903257*h1_7_vgs_w + 1.0429463084973176*h1_8_vgs_w;
      zg_vds = 0.31587620448934833*h1_1_vds + 0.652334968582689*h1_2_vds - 0.011015941304574443*h1_3_vds - 0.5749935909331874*h1_4_vds + 0.18477326374126474*h1_5_vds - 0.2156145060046444*h1_6_vds - 0.5397755313903257*h1_7_vds + 1.0429463084973176*h1_8_vds;
      zgw_vds = 0.31587620448934833*h1_1_vds_w + 0.652334968582689*h1_2_vds_w - 0.011015941304574443*h1_3_vds_w - 0.5749935909331874*h1_4_vds_w + 0.18477326374126474*h1_5_vds_w - 0.2156145060046444*h1_6_vds_w - 0.5397755313903257*h1_7_vds_w + 1.0429463084973176*h1_8_vds_w;
      zg_T = 0.31587620448934833*h1_1_T + 0.652334968582689*h1_2_T - 0.011015941304574443*h1_3_T - 0.5749935909331874*h1_4_T + 0.18477326374126474*h1_5_T - 0.2156145060046444*h1_6_T - 0.5397755313903257*h1_7_T + 1.0429463084973176*h1_8_T;
      zgw_T = 0.31587620448934833*h1_1_T_w + 0.652334968582689*h1_2_T_w - 0.011015941304574443*h1_3_T_w - 0.5749935909331874*h1_4_T_w + 0.18477326374126474*h1_5_T_w - 0.2156145060046444*h1_6_T_w - 0.5397755313903257*h1_7_T_w + 1.0429463084973176*h1_8_T_w;
      h2_4 = tanh(z);
      sl = (1.0 - h2_4*h2_4);
      h2_4_w = sl*zw;
      slw = -2.0*h2_4*h2_4_w;
      h2_4_vgs = sl*(zg_vgs);
      h2_4_vgs_w = sl*zgw_vgs + slw*zg_vgs;
      h2_4_vds = sl*(zg_vds);
      h2_4_vds_w = sl*zgw_vds + slw*zg_vds;
      h2_4_T = sl*(zg_T);
      h2_4_T_w = sl*zgw_T + slw*zg_T;
      z = -0.03826574324386326 - 0.12637967796106395*h1_1 - 1.6584965339860827*h1_2 - 0.21675062922717997*h1_3 + 0.39340038585118614*h1_4 + 0.8906320947123818*h1_5 - 0.23988539949985616*h1_6 + 0.547954966610345*h1_7 - 1.0611851455917574*h1_8;
      zw = - 0.12637967796106395*h1_1_w - 1.6584965339860827*h1_2_w - 0.21675062922717997*h1_3_w + 0.39340038585118614*h1_4_w + 0.8906320947123818*h1_5_w - 0.23988539949985616*h1_6_w + 0.547954966610345*h1_7_w - 1.0611851455917574*h1_8_w;
      zg_vgs = - 0.12637967796106395*h1_1_vgs - 1.6584965339860827*h1_2_vgs - 0.21675062922717997*h1_3_vgs + 0.39340038585118614*h1_4_vgs + 0.8906320947123818*h1_5_vgs - 0.23988539949985616*h1_6_vgs + 0.547954966610345*h1_7_vgs - 1.0611851455917574*h1_8_vgs;
      zgw_vgs = - 0.12637967796106395*h1_1_vgs_w - 1.6584965339860827*h1_2_vgs_w - 0.21675062922717997*h1_3_vgs_w + 0.39340038585118614*h1_4_vgs_w + 0.8906320947123818*h1_5_vgs_w - 0.23988539949985616*h1_6_vgs_w + 0.547954966610345*h1_7_vgs_w - 1.0611851455917574*h1_8_vgs_w;
      zg_vds = - 0.12637967796106395*h1_1_vds - 1.6584965339860827*h1_2_vds - 0.21675062922717997*h1_3_vds + 0.39340038585118614*h1_4_vds + 0.8906320947123818*h1_5_vds - 0.23988539949985616*h1_6_vds + 0.547954966610345*h1_7_vds - 1.0611851455917574*h1_8_vds;
      zgw_vds = - 0.12637967796106395*h1_1_vds_w - 1.6584965339860827*h1_2_vds_w - 0.21675062922717997*h1_3_vds_w + 0.39340038585118614*h1_4_vds_w + 0.8906320947123818*h1_5_vds_w - 0.23988539949985616*h1_6_vds_w + 0.547954966610345*h1_7_vds_w - 1.0611851455917574*h1_8_vds_w;
      zg_T = - 0.12637967796106395*h1_1_T - 1.6584965339860827*h1_2_T - 0.21675062922717997*h1_3_T + 0.39340038585118614*h1_4_T + 0.8906320947123818*h1_5_T - 0.23988539949985616*h1_6_T + 0.547954966610345*h1_7_T - 1.0611851455917574*h1_8_T;
      zgw_T = - 0.12637967796106395*h1_1_T_w - 1.6584965339860827*h1_2_T_w - 0.21675062922717997*h1_3_T_w + 0.39340038585118614*h1_4_T_w + 0.8906320947123818*h1_5_T_w - 0.23988539949985616*h1_6_T_w + 0.547954966610345*h1_7_T_w - 1.0611851455917574*h1_8_T_w;
      h2_5 = tanh(z);
      sl = (1.0 - h2_5*h2_5);
      h2_5_w = sl*zw;
      slw = -2.0*h2_5*h2_5_w;
      h2_5_vgs = sl*(zg_vgs);
      h2_5_vgs_w = sl*zgw_vgs + slw*zg_vgs;
      h2_5_vds = sl*(zg_vds);
      h2_5_vds_w = sl*zgw_vds + slw*zg_vds;
      h2_5_T = sl*(zg_T);
      h2_5_T_w = sl*zgw_T + slw*zg_T;
      z = 0.4738620533267623 - 0.8773963536685434*h1_1 + 1.9867599449822406*h1_2 + 0.07361831076568875*h1_3 - 0.4827701619951592*h1_4 - 0.07521138549670638*h1_5 + 0.19970082219928553*h1_6 + 0.2491705951139224*h1_7 - 0.602653488022388*h1_8;
      zw = - 0.8773963536685434*h1_1_w + 1.9867599449822406*h1_2_w + 0.07361831076568875*h1_3_w - 0.4827701619951592*h1_4_w - 0.07521138549670638*h1_5_w + 0.19970082219928553*h1_6_w + 0.2491705951139224*h1_7_w - 0.602653488022388*h1_8_w;
      zg_vgs = - 0.8773963536685434*h1_1_vgs + 1.9867599449822406*h1_2_vgs + 0.07361831076568875*h1_3_vgs - 0.4827701619951592*h1_4_vgs - 0.07521138549670638*h1_5_vgs + 0.19970082219928553*h1_6_vgs + 0.2491705951139224*h1_7_vgs - 0.602653488022388*h1_8_vgs;
      zgw_vgs = - 0.8773963536685434*h1_1_vgs_w + 1.9867599449822406*h1_2_vgs_w + 0.07361831076568875*h1_3_vgs_w - 0.4827701619951592*h1_4_vgs_w - 0.07521138549670638*h1_5_vgs_w + 0.19970082219928553*h1_6_vgs_w + 0.2491705951139224*h1_7_vgs_w - 0.602653488022388*h1_8_vgs_w;
      zg_vds = - 0.8773963536685434*h1_1_vds + 1.9867599449822406*h1_2_vds + 0.07361831076568875*h1_3_vds - 0.4827701619951592*h1_4_vds - 0.07521138549670638*h1_5_vds + 0.19970082219928553*h1_6_vds + 0.2491705951139224*h1_7_vds - 0.602653488022388*h1_8_vds;
      zgw_vds = - 0.8773963536685434*h1_1_vds_w + 1.9867599449822406*h1_2_vds_w + 0.07361831076568875*h1_3_vds_w - 0.4827701619951592*h1_4_vds_w - 0.07521138549670638*h1_5_vds_w + 0.19970082219928553*h1_6_vds_w + 0.2491705951139224*h1_7_vds_w - 0.602653488022388*h1_8_vds_w;
      zg_T = - 0.8773963536685434*h1_1_T + 1.9867599449822406*h1_2_T + 0.07361831076568875*h1_3_T - 0.4827701619951592*h1_4_T - 0.07521138549670638*h1_5_T + 0.19970082219928553*h1_6_T + 0.2491705951139224*h1_7_T - 0.602653488022388*h1_8_T;
      zgw_T = - 0.8773963536685434*h1_1_T_w + 1.9867599449822406*h1_2_T_w + 0.07361831076568875*h1_3_T_w - 0.4827701619951592*h1_4_T_w - 0.07521138549670638*h1_5_T_w + 0.19970082219928553*h1_6_T_w + 0.2491705951139224*h1_7_T_w - 0.602653488022388*h1_8_T_w;
      h2_6 = tanh(z);
      sl = (1.0 - h2_6*h2_6);
      h2_6_w = sl*zw;
      slw = -2.0*h2_6*h2_6_w;
      h2_6_vgs = sl*(zg_vgs);
      h2_6_vgs_w = sl*zgw_vgs + slw*zg_vgs;
      h2_6_vds = sl*(zg_vds);
      h2_6_vds_w = sl*zgw_vds + slw*zg_vds;
      h2_6_T = sl*(zg_T);
      h2_6_T_w = sl*zgw_T + slw*zg_T;
      z = -0.5575926978364787 + 0.3141123849556959*h1_1 - 0.10995362918793007*h1_2 - 0.10809822583935613*h1_3 + 0.17294110269269686*h1_4 + 0.007080277197003071*h1_5 - 0.12689658715535718*h1_6 - 0.1440910884955583*h1_7 + 0.9680940905441175*h1_8;
      zw = 0.3141123849556959*h1_1_w - 0.10995362918793007*h1_2_w - 0.10809822583935613*h1_3_w + 0.17294110269269686*h1_4_w + 0.007080277197003071*h1_5_w - 0.12689658715535718*h1_6_w - 0.1440910884955583*h1_7_w + 0.9680940905441175*h1_8_w;
      zg_vgs = 0.3141123849556959*h1_1_vgs - 0.10995362918793007*h1_2_vgs - 0.10809822583935613*h1_3_vgs + 0.17294110269269686*h1_4_vgs + 0.007080277197003071*h1_5_vgs - 0.12689658715535718*h1_6_vgs - 0.1440910884955583*h1_7_vgs + 0.9680940905441175*h1_8_vgs;
      zgw_vgs = 0.3141123849556959*h1_1_vgs_w - 0.10995362918793007*h1_2_vgs_w - 0.10809822583935613*h1_3_vgs_w + 0.17294110269269686*h1_4_vgs_w + 0.007080277197003071*h1_5_vgs_w - 0.12689658715535718*h1_6_vgs_w - 0.1440910884955583*h1_7_vgs_w + 0.9680940905441175*h1_8_vgs_w;
      zg_vds = 0.3141123849556959*h1_1_vds - 0.10995362918793007*h1_2_vds - 0.10809822583935613*h1_3_vds + 0.17294110269269686*h1_4_vds + 0.007080277197003071*h1_5_vds - 0.12689658715535718*h1_6_vds - 0.1440910884955583*h1_7_vds + 0.9680940905441175*h1_8_vds;
      zgw_vds = 0.3141123849556959*h1_1_vds_w - 0.10995362918793007*h1_2_vds_w - 0.10809822583935613*h1_3_vds_w + 0.17294110269269686*h1_4_vds_w + 0.007080277197003071*h1_5_vds_w - 0.12689658715535718*h1_6_vds_w - 0.1440910884955583*h1_7_vds_w + 0.9680940905441175*h1_8_vds_w;
      zg_T = 0.3141123849556959*h1_1_T - 0.10995362918793007*h1_2_T - 0.10809822583935613*h1_3_T + 0.17294110269269686*h1_4_T + 0.007080277197003071*h1_5_T - 0.12689658715535718*h1_6_T - 0.1440910884955583*h1_7_T + 0.9680940905441175*h1_8_T;
      zgw_T = 0.3141123849556959*h1_1_T_w - 0.10995362918793007*h1_2_T_w - 0.10809822583935613*h1_3_T_w + 0.17294110269269686*h1_4_T_w + 0.007080277197003071*h1_5_T_w - 0.12689658715535718*h1_6_T_w - 0.1440910884955583*h1_7_T_w + 0.9680940905441175*h1_8_T_w;
      h2_7 = tanh(z);
      sl = (1.0 - h2_7*h2_7);
      h2_7_w = sl*zw;
      slw = -2.0*h2_7*h2_7_w;
      h2_7_vgs = sl*(zg_vgs);
      h2_7_vgs_w = sl*zgw_vgs + slw*zg_vgs;
      h2_7_vds = sl*(zg_vds);
      h2_7_vds_w = sl*zgw_vds + slw*zg_vds;
      h2_7_T = sl*(zg_T);
      h2_7_T_w = sl*zgw_T + slw*zg_T;
      z = 0.8447032864059496 + 0.45251468136989453*h1_1 + 0.6003268764457097*h1_2 + 0.1727805887167078*h1_3 + 0.08113203378795272*h1_4 + 0.26253999795299554*h1_5 - 0.31804582738721754*h1_6 - 1.1885448737246078*h1_7 + 1.3643024505925228*h1_8;
      zw = 0.45251468136989453*h1_1_w + 0.6003268764457097*h1_2_w + 0.1727805887167078*h1_3_w + 0.08113203378795272*h1_4_w + 0.26253999795299554*h1_5_w - 0.31804582738721754*h1_6_w - 1.1885448737246078*h1_7_w + 1.3643024505925228*h1_8_w;
      zg_vgs = 0.45251468136989453*h1_1_vgs + 0.6003268764457097*h1_2_vgs + 0.1727805887167078*h1_3_vgs + 0.08113203378795272*h1_4_vgs + 0.26253999795299554*h1_5_vgs - 0.31804582738721754*h1_6_vgs - 1.1885448737246078*h1_7_vgs + 1.3643024505925228*h1_8_vgs;
      zgw_vgs = 0.45251468136989453*h1_1_vgs_w + 0.6003268764457097*h1_2_vgs_w + 0.1727805887167078*h1_3_vgs_w + 0.08113203378795272*h1_4_vgs_w + 0.26253999795299554*h1_5_vgs_w - 0.31804582738721754*h1_6_vgs_w - 1.1885448737246078*h1_7_vgs_w + 1.3643024505925228*h1_8_vgs_w;
      zg_vds = 0.45251468136989453*h1_1_vds + 0.6003268764457097*h1_2_vds + 0.1727805887167078*h1_3_vds + 0.08113203378795272*h1_4_vds + 0.26253999795299554*h1_5_vds - 0.31804582738721754*h1_6_vds - 1.1885448737246078*h1_7_vds + 1.3643024505925228*h1_8_vds;
      zgw_vds = 0.45251468136989453*h1_1_vds_w + 0.6003268764457097*h1_2_vds_w + 0.1727805887167078*h1_3_vds_w + 0.08113203378795272*h1_4_vds_w + 0.26253999795299554*h1_5_vds_w - 0.31804582738721754*h1_6_vds_w - 1.1885448737246078*h1_7_vds_w + 1.3643024505925228*h1_8_vds_w;
      zg_T = 0.45251468136989453*h1_1_T + 0.6003268764457097*h1_2_T + 0.1727805887167078*h1_3_T + 0.08113203378795272*h1_4_T + 0.26253999795299554*h1_5_T - 0.31804582738721754*h1_6_T - 1.1885448737246078*h1_7_T + 1.3643024505925228*h1_8_T;
      zgw_T = 0.45251468136989453*h1_1_T_w + 0.6003268764457097*h1_2_T_w + 0.1727805887167078*h1_3_T_w + 0.08113203378795272*h1_4_T_w + 0.26253999795299554*h1_5_T_w - 0.31804582738721754*h1_6_T_w - 1.1885448737246078*h1_7_T_w + 1.3643024505925228*h1_8_T_w;
      h2_8 = tanh(z);
      sl = (1.0 - h2_8*h2_8);
      h2_8_w = sl*zw;
      slw = -2.0*h2_8*h2_8_w;
      h2_8_vgs = sl*(zg_vgs);
      h2_8_vgs_w = sl*zgw_vgs + slw*zg_vgs;
      h2_8_vds = sl*(zg_vds);
      h2_8_vds_w = sl*zgw_vds + slw*zg_vds;
      h2_8_T = sl*(zg_T);
      h2_8_T_w = sl*zgw_T + slw*zg_T;
      // output
      z = -0.1352683009856447 - 0.14958672307798132*h2_1 + 0.5660095555065648*h2_2 - 0.6499896945736368*h2_3 + 1.8323156404733003*h2_4 - 0.4593989494528838*h2_5 - 2.131315306286907*h2_6 + 1.260210161127013*h2_7 + 1.622721543090151*h2_8;
      zw = - 0.14958672307798132*h2_1_w + 0.5660095555065648*h2_2_w - 0.6499896945736368*h2_3_w + 1.8323156404733003*h2_4_w - 0.4593989494528838*h2_5_w - 2.131315306286907*h2_6_w + 1.260210161127013*h2_7_w + 1.622721543090151*h2_8_w;
      zg_vgs = - 0.14958672307798132*h2_1_vgs + 0.5660095555065648*h2_2_vgs - 0.6499896945736368*h2_3_vgs + 1.8323156404733003*h2_4_vgs - 0.4593989494528838*h2_5_vgs - 2.131315306286907*h2_6_vgs + 1.260210161127013*h2_7_vgs + 1.622721543090151*h2_8_vgs;
      zgw_vgs = - 0.14958672307798132*h2_1_vgs_w + 0.5660095555065648*h2_2_vgs_w - 0.6499896945736368*h2_3_vgs_w + 1.8323156404733003*h2_4_vgs_w - 0.4593989494528838*h2_5_vgs_w - 2.131315306286907*h2_6_vgs_w + 1.260210161127013*h2_7_vgs_w + 1.622721543090151*h2_8_vgs_w;
      zg_vds = - 0.14958672307798132*h2_1_vds + 0.5660095555065648*h2_2_vds - 0.6499896945736368*h2_3_vds + 1.8323156404733003*h2_4_vds - 0.4593989494528838*h2_5_vds - 2.131315306286907*h2_6_vds + 1.260210161127013*h2_7_vds + 1.622721543090151*h2_8_vds;
      zgw_vds = - 0.14958672307798132*h2_1_vds_w + 0.5660095555065648*h2_2_vds_w - 0.6499896945736368*h2_3_vds_w + 1.8323156404733003*h2_4_vds_w - 0.4593989494528838*h2_5_vds_w - 2.131315306286907*h2_6_vds_w + 1.260210161127013*h2_7_vds_w + 1.622721543090151*h2_8_vds_w;
      zg_T = - 0.14958672307798132*h2_1_T + 0.5660095555065648*h2_2_T - 0.6499896945736368*h2_3_T + 1.8323156404733003*h2_4_T - 0.4593989494528838*h2_5_T - 2.131315306286907*h2_6_T + 1.260210161127013*h2_7_T + 1.622721543090151*h2_8_T;
      zgw_T = - 0.14958672307798132*h2_1_T_w + 0.5660095555065648*h2_2_T_w - 0.6499896945736368*h2_3_T_w + 1.8323156404733003*h2_4_T_w - 0.4593989494528838*h2_5_T_w - 2.131315306286907*h2_6_T_w + 1.260210161127013*h2_7_T_w + 1.622721543090151*h2_8_T_w;
      u = z;
      u_w = zw;
      u_vgs = zg_vgs;
      u_vgs_w = zgw_vgs;
      u_vds = zg_vds;
      u_vds_w = zgw_vds;
      u_T = zg_T;
      u_T_w = zgw_T;
      fh_Qd = 0.0 + 1.0700932823311475e-12*u;
      d_vgs = 1.0700932823311475e-12*u_vgs;
      hw_vgs = 1.0700932823311475e-12*u_vgs_w;
      d_vds = 1.0700932823311475e-12*u_vds;
      hw_vds = 1.0700932823311475e-12*u_vds_w;
      d_T = 1.0700932823311475e-12*u_T;
      hw_T = 1.0700932823311475e-12*u_T_w;
    end
  endfunction

  // Core.Constituents.Qd.Network continued outside its domain, with the continuation's exact gradient
  analog function real xg_Qd;
    input vgs, vds, T;
    output d_vgs, d_vds, d_T;
    real vgs, vds, T;
    real d_vgs, d_vds, d_T;
    real u_vgs, u_vds, u_T, b_vgs, b_vds, b_T, p_vgs, p_vds, p_T, g_vgs, g_vds, g_T;
    real w_vgs, w_vds, w_T, h_vgs, h_vds, h_T, q_vgs, q_vds, q_T, j_vgs, j_vds, j_T;
    real jgg, jgd, jdd, ex, ey, bx, by, t, cx, cy, e, best;
    real cr, fb, s, dist2, dist, k0, ds, o_vgs, o_vds, o_T, y_vgs, y_vds;
    real y_T, gl, ga, fo, cg;
    integer inside, inbox, onedge, interior;
    begin
      // normalised by the domain's centre and extent
      u_vgs = (vgs - (-0.9208796670951123))/2.1582407449889756;
      u_vds = (vds - 7.566235437630191)/14.867529124463616;
      u_T = (T - 64.251518025185)/78.50303605037001;
      inbox = 1;
      // Domain.Box.T: the Jacobian is one inside the interval, zero where clamped
      j_T = 0.0;
      if (u_T < (-0.5)) begin b_T = (-0.5); inbox = 0; end
      else if (u_T > 0.5) begin b_T = 0.5; inbox = 0; end
      else begin b_T = u_T; j_T = 1.0; end
      // Domain.Polygon: 10 vertices, counter-clockwise
      inside = 1;
      cr = 0.9945485555180813*(u_vds - (-0.47527975047364995)) - (-0.024720249526350158)*(u_vgs - (-0.5));
      if (cr < 0.0) inside = 0;
      cr = 0.005451444481918644*(u_vds - (-0.5000000000000001)) - 0.0018944617201674951*(u_vgs - 0.49454855551808136);
      if (cr < 0.0) inside = 0;
      cr = (-0.09398705129148938)*(u_vds - (-0.4981055382798326)) - 0.9426177824000829*(u_vgs - 0.5);
      if (cr < 0.0) inside = 0;
      cr = (-0.09249964651191961)*(u_vds - 0.44451224412025026) - 0.016160326304840433*(u_vgs - 0.4060129487085106);
      if (cr < 0.0) inside = 0;
      cr = (-0.13091432540818732)*(u_vds - 0.4606725704250907) - 0.01891242532930726*(u_vgs - 0.313513302196591);
      if (cr < 0.0) inside = 0;
      cr = (-0.14509413109986158)*(u_vds - 0.47958499575439795) - 0.013984722374358438*(u_vgs - 0.1825989767884037);
      if (cr < 0.0) inside = 0;
      cr = (-0.16824602428679386)*(u_vds - 0.4935697181287564) - 0.005939079510797307*(u_vgs - 0.037504845688542135);
      if (cr < 0.0) inside = 0;
      cr = (-0.18393634886175214)*(u_vds - 0.4995087976395537) - 0.00048644775735068313*(u_vgs - (-0.13074117859825174));
      if (cr < 0.0) inside = 0;
      cr = (-0.1853224541917186)*(u_vds - 0.4999952453969044) - 4.754603095624699e-06*(u_vgs - (-0.3146775274600039));
      if (cr < 0.0) inside = 0;
      cr = (-1.834827750846202e-08)*(u_vds - 0.5) - (-0.9752797504736499)*(u_vgs - (-0.4999999816517225));
      if (cr < 0.0) inside = 0;
      if (inside) begin
        b_vgs = u_vgs;
        b_vds = u_vds;
        jgg = 1.0; jgd = 0.0; jdd = 1.0;
      end else begin
        onedge = 0; ex = 0.0; ey = 0.0;
        t = ((u_vgs - (-0.5))*0.9945485555180813 + (u_vds - (-0.47527975047364995))*(-0.024720249526350158))/0.989737920019747;
        interior = (t > 0.0 && t < 1.0) ? 1 : 0;
        if (t < 0.0) t = 0.0; else if (t > 1.0) t = 1.0;
        cx = (-0.5) + t*0.9945485555180813;
        cy = (-0.47527975047364995) + t*(-0.024720249526350158);
        e = (u_vgs - cx)*(u_vgs - cx) + (u_vds - cy)*(u_vds - cy);
        best = e; bx = cx; by = cy; onedge = interior; ex = 0.9996912389232716; ey = (-0.024848074775611215);
        t = ((u_vgs - 0.49454855551808136)*0.005451444481918644 + (u_vds - (-0.5000000000000001))*0.0018944617201674951)/3.3307232148621213e-05;
        interior = (t > 0.0 && t < 1.0) ? 1 : 0;
        if (t < 0.0) t = 0.0; else if (t > 1.0) t = 1.0;
        cx = 0.49454855551808136 + t*0.005451444481918644;
        cy = (-0.5000000000000001) + t*0.0018944617201674951;
        e = (u_vgs - cx)*(u_vgs - cx) + (u_vds - cy)*(u_vds - cy);
        if (e < best) begin best = e; bx = cx; by = cy; onedge = interior; ex = 0.9445877770575726; ey = 0.32825893960931757; end
        t = ((u_vgs - 0.5)*(-0.09398705129148938) + (u_vds - (-0.4981055382798326))*0.9426177824000829)/0.897361849507319;
        interior = (t > 0.0 && t < 1.0) ? 1 : 0;
        if (t < 0.0) t = 0.0; else if (t > 1.0) t = 1.0;
        cx = 0.5 + t*(-0.09398705129148938);
        cy = (-0.4981055382798326) + t*0.9426177824000829;
        e = (u_vgs - cx)*(u_vgs - cx) + (u_vds - cy)*(u_vds - cy);
        if (e < best) begin best = e; bx = cx; by = cy; onedge = interior; ex = (-0.09921657329673422); ey = 0.9950658629373503; end
        t = ((u_vgs - 0.4060129487085106)*(-0.09249964651191961) + (u_vds - 0.44451224412025026)*0.016160326304840433)/0.008817340751109;
        interior = (t > 0.0 && t < 1.0) ? 1 : 0;
        if (t < 0.0) t = 0.0; else if (t > 1.0) t = 1.0;
        cx = 0.4060129487085106 + t*(-0.09249964651191961);
        cy = 0.44451224412025026 + t*0.016160326304840433;
        e = (u_vgs - cx)*(u_vgs - cx) + (u_vds - cy)*(u_vds - cy);
        if (e < best) begin best = e; bx = cx; by = cy; onedge = interior; ex = (-0.9850794534316982); ey = 0.17210017555687354; end
        t = ((u_vgs - 0.313513302196591)*(-0.13091432540818732) + (u_vds - 0.4606725704250907)*0.01891242532930726)/0.017496240428917384;
        interior = (t > 0.0 && t < 1.0) ? 1 : 0;
        if (t < 0.0) t = 0.0; else if (t > 1.0) t = 1.0;
        cx = 0.313513302196591 + t*(-0.13091432540818732);
        cy = 0.4606725704250907 + t*0.01891242532930726;
        e = (u_vgs - cx)*(u_vgs - cx) + (u_vds - cy)*(u_vds - cy);
        if (e < best) begin best = e; bx = cx; by = cy; onedge = interior; ex = (-0.9897255986340473); ey = 0.14297985665287416; end
        t = ((u_vgs - 0.1825989767884037)*(-0.14509413109986158) + (u_vds - 0.47958499575439795)*0.013984722374358438)/0.0212478793395117;
        interior = (t > 0.0 && t < 1.0) ? 1 : 0;
        if (t < 0.0) t = 0.0; else if (t > 1.0) t = 1.0;
        cx = 0.1825989767884037 + t*(-0.14509413109986158);
        cy = 0.47958499575439795 + t*0.013984722374358438;
        e = (u_vgs - cx)*(u_vgs - cx) + (u_vds - cy)*(u_vds - cy);
        if (e < best) begin best = e; bx = cx; by = cy; onedge = interior; ex = (-0.9953871968082156); ey = 0.09593919131555459; end
        t = ((u_vgs - 0.037504845688542135)*(-0.16824602428679386) + (u_vds - 0.4935697181287564)*0.005939079510797307)/0.028341997353748004;
        interior = (t > 0.0 && t < 1.0) ? 1 : 0;
        if (t < 0.0) t = 0.0; else if (t > 1.0) t = 1.0;
        cx = 0.037504845688542135 + t*(-0.16824602428679386);
        cy = 0.4935697181287564 + t*0.005939079510797307;
        e = (u_vgs - cx)*(u_vgs - cx) + (u_vds - cy)*(u_vds - cy);
        if (e < best) begin best = e; bx = cx; by = cy; onedge = interior; ex = (-0.9993775377514109); ey = 0.03527799651237496; end
        t = ((u_vgs - (-0.13074117859825174))*(-0.18393634886175214) + (u_vds - 0.4995087976395537)*0.00048644775735068313)/0.03383281706401282;
        interior = (t > 0.0 && t < 1.0) ? 1 : 0;
        if (t < 0.0) t = 0.0; else if (t > 1.0) t = 1.0;
        cx = (-0.13074117859825174) + t*(-0.18393634886175214);
        cy = 0.4995087976395537 + t*0.00048644775735068313;
        e = (u_vgs - cx)*(u_vgs - cx) + (u_vds - cy)*(u_vds - cy);
        if (e < best) begin best = e; bx = cx; by = cy; onedge = interior; ex = (-0.9999965029244544); ey = 0.0026446434281010055; end
        t = ((u_vgs - (-0.3146775274600039))*(-0.1853224541917186) + (u_vds - 0.4999952453969044)*4.754603095624699e-06)/0.034344412050247894;
        interior = (t > 0.0 && t < 1.0) ? 1 : 0;
        if (t < 0.0) t = 0.0; else if (t > 1.0) t = 1.0;
        cx = (-0.3146775274600039) + t*(-0.1853224541917186);
        cy = 0.4999952453969044 + t*4.754603095624699e-06;
        e = (u_vgs - cx)*(u_vgs - cx) + (u_vds - cy)*(u_vds - cy);
        if (e < best) begin best = e; bx = cx; by = cy; onedge = interior; ex = (-0.999999999670889); ey = 2.5655839249469495e-05; end
        t = ((u_vgs - (-0.4999999816517225))*(-1.834827750846202e-08) + (u_vds - 0.5)*(-0.9752797504736499))/0.9511705916839451;
        interior = (t > 0.0 && t < 1.0) ? 1 : 0;
        if (t < 0.0) t = 0.0; else if (t > 1.0) t = 1.0;
        cx = (-0.4999999816517225) + t*(-1.834827750846202e-08);
        cy = 0.5 + t*(-0.9752797504736499);
        e = (u_vgs - cx)*(u_vgs - cx) + (u_vds - cy)*(u_vds - cy);
        if (e < best) begin best = e; bx = cx; by = cy; onedge = interior; ex = (-1.881334816964166e-08); ey = (-0.9999999999999999); end
        b_vgs = bx;
        b_vds = by;
        if (onedge) begin jgg = ex*ex; jgd = ex*ey; jdd = ey*ey; end
        else begin jgg = 0.0; jgd = 0.0; jdd = 0.0; end
      end
      if (inside && inbox) begin
        xg_Qd = f_Qd(vgs, vds, T, d_vgs, d_vds, d_T);
      end else begin
        p_vgs = (-0.9208796670951123) + 2.1582407449889756*b_vgs;
        p_vds = 7.566235437630191 + 14.867529124463616*b_vds;
        p_T = 64.251518025185 + 78.50303605037001*b_T;
        dist2 = 0.0;
        w_vgs = vgs - p_vgs;
        dist2 = dist2 + (u_vgs - b_vgs)*(u_vgs - b_vgs);
        w_vds = vds - p_vds;
        dist2 = dist2 + (u_vds - b_vds)*(u_vds - b_vds);
        w_T = T - p_T;
        dist2 = dist2 + (u_T - b_T)*(u_T - b_T);
        dist = sqrt(dist2);
        fb = fh_Qd(p_vgs, p_vds, p_T, w_vgs, w_vds, w_T, g_vgs, g_vds, g_T, h_vgs, h_vds, h_T);
        xg_Qd = fb;
        xg_Qd = xg_Qd + g_vgs*w_vgs;
        xg_Qd = xg_Qd + g_vds*w_vds;
        xg_Qd = xg_Qd + g_T*w_T;
        q_vgs = 2.1582407449889756*g_vgs + jgg*2.1582407449889756*h_vgs + jgd*14.867529124463616*h_vds;
        q_vds = 14.867529124463616*g_vds + jgd*2.1582407449889756*h_vgs + jdd*14.867529124463616*h_vds;
        q_T = 78.50303605037001*g_T + j_T*78.50303605037001*h_T;
        d_vgs = q_vgs/2.1582407449889756;
        d_vds = q_vds/14.867529124463616;
        d_T = q_T/78.50303605037001;
      end
    end
  endfunction

  // The intrinsic charge with its temperature and trap inputs held (R-mc27-5): Qg returned, Qd and
  // C = d(Qg, Qd)/d(vgs, vds) written out, in the terminal frame and unscaled.
  analog function real qh;
    input vg, vd, Th, h_phi2;
    output oqd, c11, c12, c21, c22;
    real vg, vd, Th, h_phi2;
    real oqd, c11, c12, c21, c22;
    real e0, e1, ga_T, ga_vds, ga_vgs, gb_T, gb_vds, gb_vgs, ich, qa, qb, qc;
    real qr, ta, tb, ud, ug;
    begin
      ug = vg;
      ud = vd;
      qa = xg_Qg(ug, ud, Th, ga_vgs, ga_vds, ga_T);
      qb = xg_Qd(ug, ud, Th, gb_vgs, gb_vds, gb_T);
      c11 = ga_vgs;
      c12 = ga_vds;
      c21 = gb_vgs;
      c22 = gb_vds;
      oqd = qb;
      qh = qa;
    end
  endfunction

  real kN, Tdev, vgs, vds, ugs, uds, id, igs, igd, qg, qd, swap;
  real T;
  real Tamb, th_rf, th_cf, pw;
  real idd;
  real s_phi2;
  real bq_phi2;
  real bq_T, bq_qg, bq_qd, bq_c11, bq_c12, bq_c21, bq_c22, bq_d0, bq_d1, bq_x, bq_a, bq_b;
  real bq_c, bq_e, bq_i0, bq_i1, bq_i2, bq_i3, bq_r, bq_on, bq_y;
  // the equations' gradients, which the core does not read
  real g_vgs, g_vds, g_T, g_phi2;
  real Cpgi_N, Cpdi_N, Cpdgi_N, rg_N, rd_N, rs_N;

  analog begin
    // Periphery: N fingers of a device measured at N0 = 4
    kN = N/4.0;
    Cpgi_N = Cpgi*(N/4.0);
    Cpdi_N = Cpdi*(N/4.0);
    Cpdgi_N = Cpdgi*(N/4.0);
    rg_N = rg*(4.0/N);
    rd_N = rd*(4.0/N);
    rs_N = rs*(4.0/N);

    // Temperature: the device's own, or the simulator's
    Tdev = (Temp > -273.15) ? Temp : $temperature - `P_CELSIUS0;
    Tamb = min(max(Tdev, 25.0), 125.0);
    @(initial_step) begin
      if (Tdev < 25.0 - 1e-9 || Tdev > 125.0 + 1e-9)
        $warning("gan_4x125.cmodel covers 25.0 to 125.0 degC; the device is at %g degC, so the model is evaluated at %g degC.", Tdev, Tamb);
    end

    // Thermal: Rth x N0/N, its slope taken at the ambient, and Cth x N/N0 - or the instance's own Rth and Cth
    th_rf = (Rth > 0.0) ? Rth/25.0 : (25.0 + 0.0*(Tamb - 25.0))/25.0*(4.0/N);
    th_cf = (Cth > 0.0) ? Cth/4.0000000000000003e-07 : N/4.0;
    T = Tamb + ((SelfHeating) ? potential(ti) : 0.0);
    // the terminal joins ti only when it is wired; left unconnected it is grounded on its own, and the
    // network, which stays on the internal node, keeps heating
    if ($port_connected(t)) potential(t, ti) <+ 0.0;
    else potential(t) <+ 0.0;
    flow(ti) <+ potential(ti)/(25.0*th_rf) + ddt((4.0000000000000003e-07*th_cf)*potential(ti));   // Rth || Cth

    // Network.Netlist
    I(g, s) <+ ddt(Cpga*V(g, s));   // C1
    I(g, d) <+ ddt(Cpdga*V(g, d));   // C4
    I(d, s) <+ ddt(Cpda*V(d, s));   // C6
    V(br_L1) <+ Lg*ddt(I(br_L1));   // L1
    V(br_L1) <+ M_feedback*ddt(I(br_L2));   // M1, coupling L1 to L2
    V(br_L2) <+ Ld*ddt(I(br_L2));   // L2
    V(br_L2) <+ M_feedback*ddt(I(br_L1));   // M1, coupling L2 to L1
    V(br_L3) <+ Ls*ddt(I(br_L3));   // L3
    I(n1, gi) <+ V(n1, gi)/rg_N;   // R1
    I(n3, di) <+ V(n3, di)/rd_N;   // R2
    I(n2, si) <+ V(n2, si)/rs_N;   // R3
    I(n1, n2) <+ ddt(Cpgi_N*V(n1, n2));   // C2
    I(n1, n3) <+ ddt(Cpdgi_N*V(n1, n3));   // C3
    I(n3, n2) <+ ddt(Cpdi_N*V(n3, n2));   // C5

    // The core, on (gi, si) and (di, si), times N/N0
    vgs = V(gi, si);
    vds = V(di, si);
    ugs = vgs;
    uds = vds;
    // Traps: each state its node's voltage, or its DC value at the instantaneous voltages when its lag is off
    s_phi2 = (DrainLag) ? V(phi2) : dc_phi2(vgs, vds, T);
    id = x_Id(ugs, uds, T, s_phi2);
    igs = x_IgGs(ugs, uds, T);
    igd = x_IgGd(ugs, uds, T);
    qg = x_Qg(ugs, uds, T);
    qd = x_Qd(ugs, uds, T);
    if (!(id == id) || abs(id) > 1.0e308)
      $fatal(1, "gan_4x125.cmodel: constituent Id evaluated to %g at vgs=%g, vds=%g, T=%g.", id, ugs, uds, T);
    if (!(igs == igs) || abs(igs) > 1.0e308)
      $fatal(1, "gan_4x125.cmodel: constituent IgGs evaluated to %g at vgs=%g, vds=%g, T=%g.", igs, ugs, uds, T);
    if (!(igd == igd) || abs(igd) > 1.0e308)
      $fatal(1, "gan_4x125.cmodel: constituent IgGd evaluated to %g at vgs=%g, vds=%g, T=%g.", igd, ugs, uds, T);
    if (!(qg == qg) || abs(qg) > 1.0e308)
      $fatal(1, "gan_4x125.cmodel: constituent Qg evaluated to %g at vgs=%g, vds=%g, T=%g.", qg, ugs, uds, T);
    if (!(qd == qd) || abs(qd) > 1.0e308)
      $fatal(1, "gan_4x125.cmodel: constituent Qd evaluated to %g at vgs=%g, vds=%g, T=%g.", qd, ugs, uds, T);

    // The intrinsic charge as the switches have it
    bq_on = (Charge && (LinearC || LinearCgs || LinearCdg || LinearCds || LinearCm)) ? 1.0 : 0.0;
    @(initial_step) begin
      if (Charge && LinearC && (VgsQ <= -1e+300 || VdsQ <= -1e+300))
        $fatal(1, "gan_4x125.cmodel: LinearC=1 needs the bias point, and VgsQ or VdsQ is not set; set VgsQ and VdsQ to the intrinsic gate-source and drain-source voltages at the bias point, in V.");
      else if (Charge && LinearCgs && (VgsQ <= -1e+300 || VdsQ <= -1e+300))
        $fatal(1, "gan_4x125.cmodel: LinearCgs=1 needs the bias point, and VgsQ or VdsQ is not set; set VgsQ and VdsQ to the intrinsic gate-source and drain-source voltages at the bias point, in V.");
      else if (Charge && LinearCdg && (VgsQ <= -1e+300 || VdsQ <= -1e+300))
        $fatal(1, "gan_4x125.cmodel: LinearCdg=1 needs the bias point, and VgsQ or VdsQ is not set; set VgsQ and VdsQ to the intrinsic gate-source and drain-source voltages at the bias point, in V.");
      else if (Charge && LinearCds && (VgsQ <= -1e+300 || VdsQ <= -1e+300))
        $fatal(1, "gan_4x125.cmodel: LinearCds=1 needs the bias point, and VgsQ or VdsQ is not set; set VgsQ and VdsQ to the intrinsic gate-source and drain-source voltages at the bias point, in V.");
      else if (Charge && LinearCm && (VgsQ <= -1e+300 || VdsQ <= -1e+300))
        $fatal(1, "gan_4x125.cmodel: LinearCm=1 needs the bias point, and VgsQ or VdsQ is not set; set VgsQ and VdsQ to the intrinsic gate-source and drain-source voltages at the bias point, in V.");
      if (bq_on > 0.0 && SelfHeating && TjQ <= -273.15)
        $warning("gan_4x125.cmodel: TjQ is not set, so the charge is frozen at the ambient, %g degC, and not at the junction temperature at the bias point; set TjQ to the ambient plus the DC rise.", Tamb);
    end
    if (!Charge) begin
      qg = 0.0;
      qd = 0.0;
    end else if (bq_on > 0.0) begin
      // held at the bias point: its temperature, and every trap state at its DC value there
      bq_T = (TjQ > -273.15) ? TjQ : Tamb;
      bq_phi2 = dc_phi2(VgsQ, VdsQ, bq_T);
      bq_qg = qh(VgsQ, VdsQ, bq_T, bq_phi2, bq_qd, bq_c11, bq_c12, bq_c21, bq_c22);
      bq_d0 = vgs - VgsQ;
      bq_d1 = vds - VdsQ;
      if (LinearC) begin
        // LinearC: q(v_Q) + C(v_Q)*(v - v_Q), in the terminal frame
        qg = bq_qg + bq_c11*bq_d0 + bq_c12*bq_d1;
        qd = bq_qd + bq_c21*bq_d0 + bq_c22*bq_d1;
      end else begin
        // A branch held: the held surface, less each frozen branch's residual along the line from the bias point,
        // r_b = (integral of C_b - C_b(v_Q))*du_b by 8-point Gauss-Legendre
        qg = qh(vgs, vds, bq_T, bq_phi2, qd, bq_a, bq_b, bq_c, bq_e);
        bq_i0 = 0.0;
        bq_i1 = 0.0;
        bq_i2 = 0.0;
        bq_i3 = 0.0;
        bq_y = qh(VgsQ + 0.019855071751231856*bq_d0, VdsQ + 0.019855071751231856*bq_d1, bq_T, bq_phi2, bq_x, bq_a, bq_b, bq_c, bq_e);
        bq_i0 = bq_i0 + 0.05061426814518813*(bq_a + bq_b);
        bq_i1 = bq_i1 + 0.05061426814518813*(-bq_b);
        bq_i2 = bq_i2 + 0.05061426814518813*(bq_e + bq_b);
        bq_i3 = bq_i3 + 0.05061426814518813*(bq_c - bq_b);
        bq_y = qh(VgsQ + 0.10166676129318664*bq_d0, VdsQ + 0.10166676129318664*bq_d1, bq_T, bq_phi2, bq_x, bq_a, bq_b, bq_c, bq_e);
        bq_i0 = bq_i0 + 0.11119051722668724*(bq_a + bq_b);
        bq_i1 = bq_i1 + 0.11119051722668724*(-bq_b);
        bq_i2 = bq_i2 + 0.11119051722668724*(bq_e + bq_b);
        bq_i3 = bq_i3 + 0.11119051722668724*(bq_c - bq_b);
        bq_y = qh(VgsQ + 0.2372337950418355*bq_d0, VdsQ + 0.2372337950418355*bq_d1, bq_T, bq_phi2, bq_x, bq_a, bq_b, bq_c, bq_e);
        bq_i0 = bq_i0 + 0.15685332293894363*(bq_a + bq_b);
        bq_i1 = bq_i1 + 0.15685332293894363*(-bq_b);
        bq_i2 = bq_i2 + 0.15685332293894363*(bq_e + bq_b);
        bq_i3 = bq_i3 + 0.15685332293894363*(bq_c - bq_b);
        bq_y = qh(VgsQ + 0.4082826787521751*bq_d0, VdsQ + 0.4082826787521751*bq_d1, bq_T, bq_phi2, bq_x, bq_a, bq_b, bq_c, bq_e);
        bq_i0 = bq_i0 + 0.181341891689181*(bq_a + bq_b);
        bq_i1 = bq_i1 + 0.181341891689181*(-bq_b);
        bq_i2 = bq_i2 + 0.181341891689181*(bq_e + bq_b);
        bq_i3 = bq_i3 + 0.181341891689181*(bq_c - bq_b);
        bq_y = qh(VgsQ + 0.591717321247825*bq_d0, VdsQ + 0.591717321247825*bq_d1, bq_T, bq_phi2, bq_x, bq_a, bq_b, bq_c, bq_e);
        bq_i0 = bq_i0 + 0.181341891689181*(bq_a + bq_b);
        bq_i1 = bq_i1 + 0.181341891689181*(-bq_b);
        bq_i2 = bq_i2 + 0.181341891689181*(bq_e + bq_b);
        bq_i3 = bq_i3 + 0.181341891689181*(bq_c - bq_b);
        bq_y = qh(VgsQ + 0.7627662049581645*bq_d0, VdsQ + 0.7627662049581645*bq_d1, bq_T, bq_phi2, bq_x, bq_a, bq_b, bq_c, bq_e);
        bq_i0 = bq_i0 + 0.15685332293894363*(bq_a + bq_b);
        bq_i1 = bq_i1 + 0.15685332293894363*(-bq_b);
        bq_i2 = bq_i2 + 0.15685332293894363*(bq_e + bq_b);
        bq_i3 = bq_i3 + 0.15685332293894363*(bq_c - bq_b);
        bq_y = qh(VgsQ + 0.8983332387068134*bq_d0, VdsQ + 0.8983332387068134*bq_d1, bq_T, bq_phi2, bq_x, bq_a, bq_b, bq_c, bq_e);
        bq_i0 = bq_i0 + 0.11119051722668724*(bq_a + bq_b);
        bq_i1 = bq_i1 + 0.11119051722668724*(-bq_b);
        bq_i2 = bq_i2 + 0.11119051722668724*(bq_e + bq_b);
        bq_i3 = bq_i3 + 0.11119051722668724*(bq_c - bq_b);
        bq_y = qh(VgsQ + 0.9801449282487682*bq_d0, VdsQ + 0.9801449282487682*bq_d1, bq_T, bq_phi2, bq_x, bq_a, bq_b, bq_c, bq_e);
        bq_i0 = bq_i0 + 0.05061426814518813*(bq_a + bq_b);
        bq_i1 = bq_i1 + 0.05061426814518813*(-bq_b);
        bq_i2 = bq_i2 + 0.05061426814518813*(bq_e + bq_b);
        bq_i3 = bq_i3 + 0.05061426814518813*(bq_c - bq_b);
        if (LinearCgs) begin
          bq_r = (bq_i0 - (bq_c11 + bq_c12))*(bq_d0);
          qg = qg - bq_r;
        end
        if (LinearCdg) begin
          bq_r = (bq_i1 - (-bq_c12))*(bq_d0 - bq_d1);
          qg = qg - bq_r;
          qd = qd + bq_r;
        end
        if (LinearCds) begin
          bq_r = (bq_i2 - (bq_c22 + bq_c12))*(bq_d1);
          qd = qd - bq_r;
        end
        if (LinearCm) begin
          bq_r = (bq_i3 - (bq_c21 - bq_c12))*(bq_d0);
          qd = qd - bq_r;
        end
      end
    end
    idd = id;
    I(gi, si) <+ kN*(igs + igd);
    I(di, si) <+ kN*(idd - igd);
    I(gi, si) <+ ddt(kN*qg);
    I(di, si) <+ ddt(kN*qd);
    // Trap-state nodes, unscaled: C*dphi/dt = C*rate, C the normalised node capacitance
    if (DrainLag) begin
      I(phi2) <+ ddt(0.001*V(phi2)) - 0.001*r_phi2(V(phi2), vgs, vds, T);
    end else begin
      V(phi2) <+ 0.0;
    end
    // Self-heating: the dissipated power, ig*vgs + id*vds of the scaled currents, flows into ti
    pw = (kN*(igs + igd))*vgs + (kN*(idd - igd))*vds;
    if (SelfHeating) flow(ti) <+ -pw;
  end
endmodule
